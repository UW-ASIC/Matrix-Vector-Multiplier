* NGSPICE file created from imc_crossbar_flat.ext - technology: sky130A

.subckt imc_crossbar_flat x0 x1 x2 y2 vdd vss rst
X0 a_34203_19457# x2 a_34067_19457# SUB sky130_fd_pr__nfet_01v8 ad=0.4452 pd=2.74 as=0.4452 ps=2.74 w=0.84 l=0.15
X1 a_7617_n156# a_7569_1308# a_7481_n156# w_7405_n282# sky130_fd_pr__pfet_01v8 ad=3.71 pd=15.06 as=3.71 ps=15.06 w=7 l=0.15
X2 a_43379_18457# x2 a_43243_18457# SUB sky130_fd_pr__nfet_01v8 ad=0.2226 pd=1.9 as=0.2226 ps=1.9 w=0.42 l=0.15
X3 a_n585_n800# a_n633_n652# a_n721_n800# SUB sky130_fd_pr__nfet_01v8 ad=0.2226 pd=1.9 as=0.2226 ps=1.9 w=0.42 l=0.15
X4 a_11379_7642# x0 a_11243_7642# w_11167_7516# sky130_fd_pr__pfet_01v8 ad=0.8904 pd=4.42 as=0.8904 ps=4.42 w=1.68 l=0.15
X5 a_21351_7133# x0 a_21215_7133# SUB sky130_fd_pr__nfet_01v8 ad=0.4452 pd=2.74 as=0.4452 ps=2.74 w=0.84 l=0.15
X6 a_11379_19966# x2 a_11243_19966# w_11167_19840# sky130_fd_pr__pfet_01v8 ad=0.8904 pd=4.42 as=0.8904 ps=4.42 w=1.68 l=0.15
X7 a_11379_12603# a_11331_12835# a_11243_12603# w_11167_12477# sky130_fd_pr__pfet_01v8 ad=0.4452 pd=2.74 as=0.4452 ps=2.74 w=0.84 l=0.15
X8 a_32495_12603# a_32447_12835# a_32359_12603# w_32283_12477# sky130_fd_pr__pfet_01v8 ad=0.4452 pd=2.74 as=0.4452 ps=2.74 w=0.84 l=0.15
X9 a_32495_19966# x2 a_32359_19966# w_32283_19840# sky130_fd_pr__pfet_01v8 ad=0.8904 pd=4.42 as=0.8904 ps=4.42 w=1.68 l=0.15
X10 a_34203_18457# x2 a_34067_18457# SUB sky130_fd_pr__nfet_01v8 ad=0.2226 pd=1.9 as=0.2226 ps=1.9 w=0.42 l=0.15
X11 c1_39524_8500# x0 sky130_fd_pr__cap_mim_m3_1 l=4.8 w=38.4
X12 c1_23524_14662# x1 sky130_fd_pr__cap_mim_m3_1 l=4.8 w=38.4
X13 y2 m3_22194_372# sky130_fd_pr__cap_mim_m3_1 l=15.8 w=15.8
X14 a_21351_6133# x0 a_21215_6133# SUB sky130_fd_pr__nfet_01v8 ad=0.2226 pd=1.9 as=0.2226 ps=1.9 w=0.42 l=0.15
X15 a_16495_6441# a_16447_6673# a_16359_6441# w_16283_6315# sky130_fd_pr__pfet_01v8 ad=0.4452 pd=2.74 as=0.4452 ps=2.74 w=0.84 l=0.15
X16 a_32495_7642# x0 a_32359_7642# w_32283_7516# sky130_fd_pr__pfet_01v8 ad=0.8904 pd=4.42 as=0.8904 ps=4.42 w=1.68 l=0.15
X17 a_495_6441# a_447_6673# a_359_6441# w_283_6315# sky130_fd_pr__pfet_01v8 ad=0.4452 pd=2.74 as=0.4452 ps=2.74 w=0.84 l=0.15
X18 a_37351_7642# x0 a_37215_7642# w_37139_7516# sky130_fd_pr__pfet_01v8 ad=0.8904 pd=4.42 as=0.8904 ps=4.42 w=1.68 l=0.15
X19 a_495_13295# x1 a_359_13295# SUB sky130_fd_pr__nfet_01v8 ad=0.4452 pd=2.74 as=0.4452 ps=2.74 w=0.84 l=0.15
X20 a_43379_6441# a_43331_6673# a_43243_6441# w_43167_6315# sky130_fd_pr__pfet_01v8 ad=0.4452 pd=2.74 as=0.4452 ps=2.74 w=0.84 l=0.15
X21 a_495_18765# a_447_18997# a_359_18765# w_283_18639# sky130_fd_pr__pfet_01v8 ad=0.4452 pd=2.74 as=0.4452 ps=2.74 w=0.84 l=0.15
X22 a_27379_19966# x2 a_27243_19966# w_27167_19840# sky130_fd_pr__pfet_01v8 ad=0.8904 pd=4.42 as=0.8904 ps=4.42 w=1.68 l=0.15
X23 a_27379_12603# a_27331_12835# a_27243_12603# w_27167_12477# sky130_fd_pr__pfet_01v8 ad=0.4452 pd=2.74 as=0.4452 ps=2.74 w=0.84 l=0.15
X24 a_21351_12603# a_21303_12835# a_21215_12603# w_21139_12477# sky130_fd_pr__pfet_01v8 ad=0.4452 pd=2.74 as=0.4452 ps=2.74 w=0.84 l=0.15
X25 a_21351_19966# x2 a_21215_19966# w_21139_19840# sky130_fd_pr__pfet_01v8 ad=0.8904 pd=4.42 as=0.8904 ps=4.42 w=1.68 l=0.15
X26 c1_0_8500# x0 sky130_fd_pr__cap_mim_m3_1 l=4.8 w=4.8
X27 a_18203_19966# x2 a_18067_19966# w_17991_19840# sky130_fd_pr__pfet_01v8 ad=0.8904 pd=4.42 as=0.8904 ps=4.42 w=1.68 l=0.15
X28 a_18203_12603# a_18155_12835# a_18067_12603# w_17991_12477# sky130_fd_pr__pfet_01v8 ad=0.4452 pd=2.74 as=0.4452 ps=2.74 w=0.84 l=0.15
X29 a_495_12295# x1 a_359_12295# SUB sky130_fd_pr__nfet_01v8 ad=0.2226 pd=1.9 as=0.2226 ps=1.9 w=0.42 l=0.15
X30 a_16495_7133# x0 a_16359_7133# SUB sky130_fd_pr__nfet_01v8 ad=0.4452 pd=2.74 as=0.4452 ps=2.74 w=0.84 l=0.15
X31 a_n585_n586# a_n633_n652# a_n721_n616# w_n797_n742# sky130_fd_pr__pfet_01v8 ad=0.4317 pd=2.74 as=0.4317 ps=2.74 w=0.81 l=0.15
X32 a_34203_6441# a_34155_6673# a_34067_6441# w_33991_6315# sky130_fd_pr__pfet_01v8 ad=0.4452 pd=2.74 as=0.4452 ps=2.74 w=0.84 l=0.15
X33 a_495_7133# x0 a_359_7133# SUB sky130_fd_pr__nfet_01v8 ad=0.4452 pd=2.74 as=0.4452 ps=2.74 w=0.84 l=0.15
X34 a_2203_7642# x0 a_2067_7642# w_1991_7516# sky130_fd_pr__pfet_01v8 ad=0.8904 pd=4.42 as=0.8904 ps=4.42 w=1.68 l=0.15
X35 a_5351_13295# x1 a_5215_13295# SUB sky130_fd_pr__nfet_01v8 ad=0.4452 pd=2.74 as=0.4452 ps=2.74 w=0.84 l=0.15
X36 a_43379_7133# x0 a_43243_7133# SUB sky130_fd_pr__nfet_01v8 ad=0.4452 pd=2.74 as=0.4452 ps=2.74 w=0.84 l=0.15
X37 a_495_19457# x2 a_359_19457# SUB sky130_fd_pr__nfet_01v8 ad=0.4452 pd=2.74 as=0.4452 ps=2.74 w=0.84 l=0.15
X38 a_5351_18765# a_5303_18997# a_5215_18765# w_5139_18639# sky130_fd_pr__pfet_01v8 ad=0.4452 pd=2.74 as=0.4452 ps=2.74 w=0.84 l=0.15
X39 c1_3416_14662# x1 sky130_fd_pr__cap_mim_m3_1 l=4.8 w=19.2
X40 a_16495_6133# x0 a_16359_6133# SUB sky130_fd_pr__nfet_01v8 ad=0.2226 pd=1.9 as=0.2226 ps=1.9 w=0.42 l=0.15
X41 a_495_6133# x0 a_359_6133# SUB sky130_fd_pr__nfet_01v8 ad=0.2226 pd=1.9 as=0.2226 ps=1.9 w=0.42 l=0.15
X42 a_37351_12603# a_37303_12835# a_37215_12603# w_37139_12477# sky130_fd_pr__pfet_01v8 ad=0.4452 pd=2.74 as=0.4452 ps=2.74 w=0.84 l=0.15
X43 a_37351_19966# x2 a_37215_19966# w_37139_19840# sky130_fd_pr__pfet_01v8 ad=0.8904 pd=4.42 as=0.8904 ps=4.42 w=1.68 l=0.15
X44 a_43379_6133# x0 a_43243_6133# SUB sky130_fd_pr__nfet_01v8 ad=0.2226 pd=1.9 as=0.2226 ps=1.9 w=0.42 l=0.15
X45 a_495_18457# x2 a_359_18457# SUB sky130_fd_pr__nfet_01v8 ad=0.2226 pd=1.9 as=0.2226 ps=1.9 w=0.42 l=0.15
X46 a_5351_12295# x1 a_5215_12295# SUB sky130_fd_pr__nfet_01v8 ad=0.2226 pd=1.9 as=0.2226 ps=1.9 w=0.42 l=0.15
X47 a_34203_7133# x0 a_34067_7133# SUB sky130_fd_pr__nfet_01v8 ad=0.4452 pd=2.74 as=0.4452 ps=2.74 w=0.84 l=0.15
X48 c1_1228_14662# x1 sky130_fd_pr__cap_mim_m3_1 l=4.8 w=9.6
X49 a_16495_13804# x1 a_16359_13804# w_16283_13678# sky130_fd_pr__pfet_01v8 ad=0.8904 pd=4.42 as=0.8904 ps=4.42 w=1.68 l=0.15
X50 a_5351_19457# x2 a_5215_19457# SUB sky130_fd_pr__nfet_01v8 ad=0.4452 pd=2.74 as=0.4452 ps=2.74 w=0.84 l=0.15
X51 a_34203_6133# x0 a_34067_6133# SUB sky130_fd_pr__nfet_01v8 ad=0.2226 pd=1.9 as=0.2226 ps=1.9 w=0.42 l=0.15
X52 a_23617_n156# a_23569_1308# a_23481_n156# w_23405_n282# sky130_fd_pr__pfet_01v8 ad=3.71 pd=15.06 as=3.71 ps=15.06 w=7 l=0.15
X53 c1_33228_8500# x0 sky130_fd_pr__cap_mim_m3_1 l=4.8 w=9.6
X54 a_5351_18457# x2 a_5215_18457# SUB sky130_fd_pr__nfet_01v8 ad=0.2226 pd=1.9 as=0.2226 ps=1.9 w=0.42 l=0.15
X55 c1_19416_14662# x1 sky130_fd_pr__cap_mim_m3_1 l=4.8 w=19.2
X56 a_39617_n719# a_39569_n403# a_39481_n719# SUB sky130_fd_pr__nfet_01v8 ad=0.6678 pd=3.58 as=0.6678 ps=3.58 w=1.26 l=0.15
X57 a_43379_13804# x1 a_43243_13804# w_43167_13678# sky130_fd_pr__pfet_01v8 ad=0.8904 pd=4.42 as=0.8904 ps=4.42 w=1.68 l=0.15
X58 a_2203_12603# a_2155_12835# a_2067_12603# w_1991_12477# sky130_fd_pr__pfet_01v8 ad=0.4452 pd=2.74 as=0.4452 ps=2.74 w=0.84 l=0.15
X59 a_2203_19966# x2 a_2067_19966# w_1991_19840# sky130_fd_pr__pfet_01v8 ad=0.8904 pd=4.42 as=0.8904 ps=4.42 w=1.68 l=0.15
X60 a_34203_13804# x1 a_34067_13804# w_33991_13678# sky130_fd_pr__pfet_01v8 ad=0.8904 pd=4.42 as=0.8904 ps=4.42 w=1.68 l=0.15
X61 c1_16000_14662# x1 sky130_fd_pr__cap_mim_m3_1 l=4.8 w=4.8
X62 c1_35416_20824# x2 sky130_fd_pr__cap_mim_m3_1 l=4.8 w=19.2
X63 c1_32000_20824# x2 sky130_fd_pr__cap_mim_m3_1 l=4.8 w=4.8
X64 c1_17228_14662# x1 sky130_fd_pr__cap_mim_m3_1 l=4.8 w=9.6
X65 a_11379_6441# a_11331_6673# a_11243_6441# w_11167_6315# sky130_fd_pr__pfet_01v8 ad=0.4452 pd=2.74 as=0.4452 ps=2.74 w=0.84 l=0.15
X66 a_11379_18765# a_11331_18997# a_11243_18765# w_11167_18639# sky130_fd_pr__pfet_01v8 ad=0.4452 pd=2.74 as=0.4452 ps=2.74 w=0.84 l=0.15
X67 a_11379_13295# x1 a_11243_13295# SUB sky130_fd_pr__nfet_01v8 ad=0.4452 pd=2.74 as=0.4452 ps=2.74 w=0.84 l=0.15
X68 a_32495_13295# x1 a_32359_13295# SUB sky130_fd_pr__nfet_01v8 ad=0.4452 pd=2.74 as=0.4452 ps=2.74 w=0.84 l=0.15
X69 c1_32000_8500# x0 sky130_fd_pr__cap_mim_m3_1 l=4.8 w=4.8
X70 c1_7524_14662# x1 sky130_fd_pr__cap_mim_m3_1 l=4.8 w=38.4
X71 a_32495_18765# a_32447_18997# a_32359_18765# w_32283_18639# sky130_fd_pr__pfet_01v8 ad=0.4452 pd=2.74 as=0.4452 ps=2.74 w=0.84 l=0.15
X72 c1_33228_20824# x2 sky130_fd_pr__cap_mim_m3_1 l=4.8 w=9.6
X73 a_11379_12295# x1 a_11243_12295# SUB sky130_fd_pr__nfet_01v8 ad=0.2226 pd=1.9 as=0.2226 ps=1.9 w=0.42 l=0.15
X74 a_32495_6441# a_32447_6673# a_32359_6441# w_32283_6315# sky130_fd_pr__pfet_01v8 ad=0.4452 pd=2.74 as=0.4452 ps=2.74 w=0.84 l=0.15
X75 a_32495_12295# x1 a_32359_12295# SUB sky130_fd_pr__nfet_01v8 ad=0.2226 pd=1.9 as=0.2226 ps=1.9 w=0.42 l=0.15
X76 c1_19416_8500# x0 sky130_fd_pr__cap_mim_m3_1 l=4.8 w=19.2
X77 a_37351_6441# a_37303_6673# a_37215_6441# w_37139_6315# sky130_fd_pr__pfet_01v8 ad=0.4452 pd=2.74 as=0.4452 ps=2.74 w=0.84 l=0.15
X78 a_11379_7133# x0 a_11243_7133# SUB sky130_fd_pr__nfet_01v8 ad=0.4452 pd=2.74 as=0.4452 ps=2.74 w=0.84 l=0.15
X79 a_5351_7642# x0 a_5215_7642# w_5139_7516# sky130_fd_pr__pfet_01v8 ad=0.8904 pd=4.42 as=0.8904 ps=4.42 w=1.68 l=0.15
X80 a_27379_13295# x1 a_27243_13295# SUB sky130_fd_pr__nfet_01v8 ad=0.4452 pd=2.74 as=0.4452 ps=2.74 w=0.84 l=0.15
X81 a_11379_19457# x2 a_11243_19457# SUB sky130_fd_pr__nfet_01v8 ad=0.4452 pd=2.74 as=0.4452 ps=2.74 w=0.84 l=0.15
X82 a_27379_18765# a_27331_18997# a_27243_18765# w_27167_18639# sky130_fd_pr__pfet_01v8 ad=0.4452 pd=2.74 as=0.4452 ps=2.74 w=0.84 l=0.15
X83 a_32495_19457# x2 a_32359_19457# SUB sky130_fd_pr__nfet_01v8 ad=0.4452 pd=2.74 as=0.4452 ps=2.74 w=0.84 l=0.15
X84 a_21351_13295# x1 a_21215_13295# SUB sky130_fd_pr__nfet_01v8 ad=0.4452 pd=2.74 as=0.4452 ps=2.74 w=0.84 l=0.15
X85 a_21351_18765# a_21303_18997# a_21215_18765# w_21139_18639# sky130_fd_pr__pfet_01v8 ad=0.4452 pd=2.74 as=0.4452 ps=2.74 w=0.84 l=0.15
X86 a_18203_13295# x1 a_18067_13295# SUB sky130_fd_pr__nfet_01v8 ad=0.4452 pd=2.74 as=0.4452 ps=2.74 w=0.84 l=0.15
X87 a_18203_18765# a_18155_18997# a_18067_18765# w_17991_18639# sky130_fd_pr__pfet_01v8 ad=0.4452 pd=2.74 as=0.4452 ps=2.74 w=0.84 l=0.15
X88 a_11379_6133# x0 a_11243_6133# SUB sky130_fd_pr__nfet_01v8 ad=0.2226 pd=1.9 as=0.2226 ps=1.9 w=0.42 l=0.15
X89 a_27379_12295# x1 a_27243_12295# SUB sky130_fd_pr__nfet_01v8 ad=0.2226 pd=1.9 as=0.2226 ps=1.9 w=0.42 l=0.15
X90 c1_0_20824# x2 sky130_fd_pr__cap_mim_m3_1 l=4.8 w=4.8
X91 a_32495_7133# x0 a_32359_7133# SUB sky130_fd_pr__nfet_01v8 ad=0.4452 pd=2.74 as=0.4452 ps=2.74 w=0.84 l=0.15
X92 a_11379_18457# x2 a_11243_18457# SUB sky130_fd_pr__nfet_01v8 ad=0.2226 pd=1.9 as=0.2226 ps=1.9 w=0.42 l=0.15
X93 a_32495_18457# x2 a_32359_18457# SUB sky130_fd_pr__nfet_01v8 ad=0.2226 pd=1.9 as=0.2226 ps=1.9 w=0.42 l=0.15
X94 a_37351_7133# x0 a_37215_7133# SUB sky130_fd_pr__nfet_01v8 ad=0.4452 pd=2.74 as=0.4452 ps=2.74 w=0.84 l=0.15
X95 a_27379_7642# x0 a_27243_7642# w_27167_7516# sky130_fd_pr__pfet_01v8 ad=0.8904 pd=4.42 as=0.8904 ps=4.42 w=1.68 l=0.15
X96 a_495_13804# x1 a_359_13804# w_283_13678# sky130_fd_pr__pfet_01v8 ad=0.8904 pd=4.42 as=0.8904 ps=4.42 w=1.68 l=0.15
X97 a_21351_12295# x1 a_21215_12295# SUB sky130_fd_pr__nfet_01v8 ad=0.2226 pd=1.9 as=0.2226 ps=1.9 w=0.42 l=0.15
X98 a_2203_6441# a_2155_6673# a_2067_6441# w_1991_6315# sky130_fd_pr__pfet_01v8 ad=0.4452 pd=2.74 as=0.4452 ps=2.74 w=0.84 l=0.15
X99 a_18203_12295# x1 a_18067_12295# SUB sky130_fd_pr__nfet_01v8 ad=0.2226 pd=1.9 as=0.2226 ps=1.9 w=0.42 l=0.15
X100 a_27379_19457# x2 a_27243_19457# SUB sky130_fd_pr__nfet_01v8 ad=0.4452 pd=2.74 as=0.4452 ps=2.74 w=0.84 l=0.15
X101 a_32495_6133# x0 a_32359_6133# SUB sky130_fd_pr__nfet_01v8 ad=0.2226 pd=1.9 as=0.2226 ps=1.9 w=0.42 l=0.15
X102 a_37351_13295# x1 a_37215_13295# SUB sky130_fd_pr__nfet_01v8 ad=0.4452 pd=2.74 as=0.4452 ps=2.74 w=0.84 l=0.15
X103 y2 m3_38194_372# sky130_fd_pr__cap_mim_m3_1 l=15.8 w=15.8
X104 c1_39524_20824# x2 sky130_fd_pr__cap_mim_m3_1 l=4.8 w=38.4
X105 a_37351_6133# x0 a_37215_6133# SUB sky130_fd_pr__nfet_01v8 ad=0.2226 pd=1.9 as=0.2226 ps=1.9 w=0.42 l=0.15
X106 a_21351_19457# x2 a_21215_19457# SUB sky130_fd_pr__nfet_01v8 ad=0.4452 pd=2.74 as=0.4452 ps=2.74 w=0.84 l=0.15
X107 a_37351_18765# a_37303_18997# a_37215_18765# w_37139_18639# sky130_fd_pr__pfet_01v8 ad=0.4452 pd=2.74 as=0.4452 ps=2.74 w=0.84 l=0.15
X108 a_18203_19457# x2 a_18067_19457# SUB sky130_fd_pr__nfet_01v8 ad=0.4452 pd=2.74 as=0.4452 ps=2.74 w=0.84 l=0.15
X109 a_18203_7642# x0 a_18067_7642# w_17991_7516# sky130_fd_pr__pfet_01v8 ad=0.8904 pd=4.42 as=0.8904 ps=4.42 w=1.68 l=0.15
X110 a_27379_18457# x2 a_27243_18457# SUB sky130_fd_pr__nfet_01v8 ad=0.2226 pd=1.9 as=0.2226 ps=1.9 w=0.42 l=0.15
X111 a_21351_18457# x2 a_21215_18457# SUB sky130_fd_pr__nfet_01v8 ad=0.2226 pd=1.9 as=0.2226 ps=1.9 w=0.42 l=0.15
X112 a_5351_13804# x1 a_5215_13804# w_5139_13678# sky130_fd_pr__pfet_01v8 ad=0.8904 pd=4.42 as=0.8904 ps=4.42 w=1.68 l=0.15
X113 a_37351_12295# x1 a_37215_12295# SUB sky130_fd_pr__nfet_01v8 ad=0.2226 pd=1.9 as=0.2226 ps=1.9 w=0.42 l=0.15
X114 a_2203_7133# x0 a_2067_7133# SUB sky130_fd_pr__nfet_01v8 ad=0.4452 pd=2.74 as=0.4452 ps=2.74 w=0.84 l=0.15
X115 a_16495_19966# x2 a_16359_19966# w_16283_19840# sky130_fd_pr__pfet_01v8 ad=0.8904 pd=4.42 as=0.8904 ps=4.42 w=1.68 l=0.15
X116 a_18203_18457# x2 a_18067_18457# SUB sky130_fd_pr__nfet_01v8 ad=0.2226 pd=1.9 as=0.2226 ps=1.9 w=0.42 l=0.15
X117 a_16495_12603# a_16447_12835# a_16359_12603# w_16283_12477# sky130_fd_pr__pfet_01v8 ad=0.4452 pd=2.74 as=0.4452 ps=2.74 w=0.84 l=0.15
X118 c1_3416_8500# x0 sky130_fd_pr__cap_mim_m3_1 l=4.8 w=19.2
X119 a_37351_19457# x2 a_37215_19457# SUB sky130_fd_pr__nfet_01v8 ad=0.4452 pd=2.74 as=0.4452 ps=2.74 w=0.84 l=0.15
X120 a_2203_6133# x0 a_2067_6133# SUB sky130_fd_pr__nfet_01v8 ad=0.2226 pd=1.9 as=0.2226 ps=1.9 w=0.42 l=0.15
X121 a_2203_13295# x1 a_2067_13295# SUB sky130_fd_pr__nfet_01v8 ad=0.4452 pd=2.74 as=0.4452 ps=2.74 w=0.84 l=0.15
X122 a_43379_12603# a_43331_12835# a_43243_12603# w_43167_12477# sky130_fd_pr__pfet_01v8 ad=0.4452 pd=2.74 as=0.4452 ps=2.74 w=0.84 l=0.15
X123 a_43379_19966# x2 a_43243_19966# w_43167_19840# sky130_fd_pr__pfet_01v8 ad=0.8904 pd=4.42 as=0.8904 ps=4.42 w=1.68 l=0.15
X124 a_2203_18765# a_2155_18997# a_2067_18765# w_1991_18639# sky130_fd_pr__pfet_01v8 ad=0.4452 pd=2.74 as=0.4452 ps=2.74 w=0.84 l=0.15
X125 a_37351_18457# x2 a_37215_18457# SUB sky130_fd_pr__nfet_01v8 ad=0.2226 pd=1.9 as=0.2226 ps=1.9 w=0.42 l=0.15
X126 a_7617_n719# a_7569_n403# a_7481_n719# SUB sky130_fd_pr__nfet_01v8 ad=0.6678 pd=3.58 as=0.6678 ps=3.58 w=1.26 l=0.15
X127 a_34203_19966# x2 a_34067_19966# w_33991_19840# sky130_fd_pr__pfet_01v8 ad=0.8904 pd=4.42 as=0.8904 ps=4.42 w=1.68 l=0.15
X128 a_34203_12603# a_34155_12835# a_34067_12603# w_33991_12477# sky130_fd_pr__pfet_01v8 ad=0.4452 pd=2.74 as=0.4452 ps=2.74 w=0.84 l=0.15
X129 a_2203_12295# x1 a_2067_12295# SUB sky130_fd_pr__nfet_01v8 ad=0.2226 pd=1.9 as=0.2226 ps=1.9 w=0.42 l=0.15
X130 c1_23524_20824# x2 sky130_fd_pr__cap_mim_m3_1 l=4.8 w=38.4
X131 a_21351_7642# x0 a_21215_7642# w_21139_7516# sky130_fd_pr__pfet_01v8 ad=0.8904 pd=4.42 as=0.8904 ps=4.42 w=1.68 l=0.15
X132 a_2203_19457# x2 a_2067_19457# SUB sky130_fd_pr__nfet_01v8 ad=0.4452 pd=2.74 as=0.4452 ps=2.74 w=0.84 l=0.15
X133 a_39617_n156# a_39569_1308# a_39481_n156# w_39405_n282# sky130_fd_pr__pfet_01v8 ad=3.71 pd=15.06 as=3.71 ps=15.06 w=7 l=0.15
X134 a_2203_18457# x2 a_2067_18457# SUB sky130_fd_pr__nfet_01v8 ad=0.2226 pd=1.9 as=0.2226 ps=1.9 w=0.42 l=0.15
X135 a_5351_6441# a_5303_6673# a_5215_6441# w_5139_6315# sky130_fd_pr__pfet_01v8 ad=0.4452 pd=2.74 as=0.4452 ps=2.74 w=0.84 l=0.15
X136 a_11379_13804# x1 a_11243_13804# w_11167_13678# sky130_fd_pr__pfet_01v8 ad=0.8904 pd=4.42 as=0.8904 ps=4.42 w=1.68 l=0.15
X137 a_32495_13804# x1 a_32359_13804# w_32283_13678# sky130_fd_pr__pfet_01v8 ad=0.8904 pd=4.42 as=0.8904 ps=4.42 w=1.68 l=0.15
X138 c1_7524_8500# x0 sky130_fd_pr__cap_mim_m3_1 l=4.8 w=38.4
X139 c1_35416_14662# x1 sky130_fd_pr__cap_mim_m3_1 l=4.8 w=19.2
X140 c1_3416_20824# x2 sky130_fd_pr__cap_mim_m3_1 l=4.8 w=19.2
X141 c1_32000_14662# x1 sky130_fd_pr__cap_mim_m3_1 l=4.8 w=4.8
X142 a_16495_7642# x0 a_16359_7642# w_16283_7516# sky130_fd_pr__pfet_01v8 ad=0.8904 pd=4.42 as=0.8904 ps=4.42 w=1.68 l=0.15
X143 a_495_7642# x0 a_359_7642# w_283_7516# sky130_fd_pr__pfet_01v8 ad=0.8904 pd=4.42 as=0.8904 ps=4.42 w=1.68 l=0.15
X144 c1_17228_8500# x0 sky130_fd_pr__cap_mim_m3_1 l=4.8 w=9.6
X145 a_27379_6441# a_27331_6673# a_27243_6441# w_27167_6315# sky130_fd_pr__pfet_01v8 ad=0.4452 pd=2.74 as=0.4452 ps=2.74 w=0.84 l=0.15
X146 a_495_12603# a_447_12835# a_359_12603# w_283_12477# sky130_fd_pr__pfet_01v8 ad=0.4452 pd=2.74 as=0.4452 ps=2.74 w=0.84 l=0.15
X147 a_43379_7642# x0 a_43243_7642# w_43167_7516# sky130_fd_pr__pfet_01v8 ad=0.8904 pd=4.42 as=0.8904 ps=4.42 w=1.68 l=0.15
X148 a_495_19966# x2 a_359_19966# w_283_19840# sky130_fd_pr__pfet_01v8 ad=0.8904 pd=4.42 as=0.8904 ps=4.42 w=1.68 l=0.15
X149 c1_33228_14662# x1 sky130_fd_pr__cap_mim_m3_1 l=4.8 w=9.6
X150 a_5351_7133# x0 a_5215_7133# SUB sky130_fd_pr__nfet_01v8 ad=0.4452 pd=2.74 as=0.4452 ps=2.74 w=0.84 l=0.15
X151 a_27379_13804# x1 a_27243_13804# w_27167_13678# sky130_fd_pr__pfet_01v8 ad=0.8904 pd=4.42 as=0.8904 ps=4.42 w=1.68 l=0.15
X152 a_21351_13804# x1 a_21215_13804# w_21139_13678# sky130_fd_pr__pfet_01v8 ad=0.8904 pd=4.42 as=0.8904 ps=4.42 w=1.68 l=0.15
X153 a_18203_13804# x1 a_18067_13804# w_17991_13678# sky130_fd_pr__pfet_01v8 ad=0.8904 pd=4.42 as=0.8904 ps=4.42 w=1.68 l=0.15
X154 c1_1228_20824# x2 sky130_fd_pr__cap_mim_m3_1 l=4.8 w=9.6
X155 y2 m3_6194_372# sky130_fd_pr__cap_mim_m3_1 l=15.8 w=15.8
X156 a_5351_6133# x0 a_5215_6133# SUB sky130_fd_pr__nfet_01v8 ad=0.2226 pd=1.9 as=0.2226 ps=1.9 w=0.42 l=0.15
X157 a_18203_6441# a_18155_6673# a_18067_6441# w_17991_6315# sky130_fd_pr__pfet_01v8 ad=0.4452 pd=2.74 as=0.4452 ps=2.74 w=0.84 l=0.15
X158 a_34203_7642# x0 a_34067_7642# w_33991_7516# sky130_fd_pr__pfet_01v8 ad=0.8904 pd=4.42 as=0.8904 ps=4.42 w=1.68 l=0.15
X159 a_27379_7133# x0 a_27243_7133# SUB sky130_fd_pr__nfet_01v8 ad=0.4452 pd=2.74 as=0.4452 ps=2.74 w=0.84 l=0.15
X160 a_23617_n719# a_23569_n403# a_23481_n719# SUB sky130_fd_pr__nfet_01v8 ad=0.6678 pd=3.58 as=0.6678 ps=3.58 w=1.26 l=0.15
X161 a_5351_19966# x2 a_5215_19966# w_5139_19840# sky130_fd_pr__pfet_01v8 ad=0.8904 pd=4.42 as=0.8904 ps=4.42 w=1.68 l=0.15
X162 a_16495_18765# a_16447_18997# a_16359_18765# w_16283_18639# sky130_fd_pr__pfet_01v8 ad=0.4452 pd=2.74 as=0.4452 ps=2.74 w=0.84 l=0.15
X163 a_16495_13295# x1 a_16359_13295# SUB sky130_fd_pr__nfet_01v8 ad=0.4452 pd=2.74 as=0.4452 ps=2.74 w=0.84 l=0.15
X164 a_5351_12603# a_5303_12835# a_5215_12603# w_5139_12477# sky130_fd_pr__pfet_01v8 ad=0.4452 pd=2.74 as=0.4452 ps=2.74 w=0.84 l=0.15
X165 c1_16000_8500# x0 sky130_fd_pr__cap_mim_m3_1 l=4.8 w=4.8
X166 c1_19416_20824# x2 sky130_fd_pr__cap_mim_m3_1 l=4.8 w=19.2
X167 c1_0_14662# x1 sky130_fd_pr__cap_mim_m3_1 l=4.8 w=4.8
X168 a_37351_13804# x1 a_37215_13804# w_37139_13678# sky130_fd_pr__pfet_01v8 ad=0.8904 pd=4.42 as=0.8904 ps=4.42 w=1.68 l=0.15
X169 a_27379_6133# x0 a_27243_6133# SUB sky130_fd_pr__nfet_01v8 ad=0.2226 pd=1.9 as=0.2226 ps=1.9 w=0.42 l=0.15
X170 c1_35416_8500# x0 sky130_fd_pr__cap_mim_m3_1 l=4.8 w=19.2
X171 a_16495_12295# x1 a_16359_12295# SUB sky130_fd_pr__nfet_01v8 ad=0.2226 pd=1.9 as=0.2226 ps=1.9 w=0.42 l=0.15
X172 c1_16000_20824# x2 sky130_fd_pr__cap_mim_m3_1 l=4.8 w=4.8
X173 a_18203_7133# x0 a_18067_7133# SUB sky130_fd_pr__nfet_01v8 ad=0.4452 pd=2.74 as=0.4452 ps=2.74 w=0.84 l=0.15
X174 a_43379_13295# x1 a_43243_13295# SUB sky130_fd_pr__nfet_01v8 ad=0.4452 pd=2.74 as=0.4452 ps=2.74 w=0.84 l=0.15
X175 c1_39524_14662# x1 sky130_fd_pr__cap_mim_m3_1 l=4.8 w=38.4
X176 a_43379_18765# a_43331_18997# a_43243_18765# w_43167_18639# sky130_fd_pr__pfet_01v8 ad=0.4452 pd=2.74 as=0.4452 ps=2.74 w=0.84 l=0.15
X177 c1_17228_20824# x2 sky130_fd_pr__cap_mim_m3_1 l=4.8 w=9.6
X178 a_16495_19457# x2 a_16359_19457# SUB sky130_fd_pr__nfet_01v8 ad=0.4452 pd=2.74 as=0.4452 ps=2.74 w=0.84 l=0.15
X179 a_18203_6133# x0 a_18067_6133# SUB sky130_fd_pr__nfet_01v8 ad=0.2226 pd=1.9 as=0.2226 ps=1.9 w=0.42 l=0.15
X180 a_34203_13295# x1 a_34067_13295# SUB sky130_fd_pr__nfet_01v8 ad=0.4452 pd=2.74 as=0.4452 ps=2.74 w=0.84 l=0.15
X181 c1_1228_8500# x0 sky130_fd_pr__cap_mim_m3_1 l=4.8 w=9.6
X182 c1_7524_20824# x2 sky130_fd_pr__cap_mim_m3_1 l=4.8 w=38.4
X183 a_34203_18765# a_34155_18997# a_34067_18765# w_33991_18639# sky130_fd_pr__pfet_01v8 ad=0.4452 pd=2.74 as=0.4452 ps=2.74 w=0.84 l=0.15
X184 a_43379_12295# x1 a_43243_12295# SUB sky130_fd_pr__nfet_01v8 ad=0.2226 pd=1.9 as=0.2226 ps=1.9 w=0.42 l=0.15
X185 a_21351_6441# a_21303_6673# a_21215_6441# w_21139_6315# sky130_fd_pr__pfet_01v8 ad=0.4452 pd=2.74 as=0.4452 ps=2.74 w=0.84 l=0.15
X186 a_16495_18457# x2 a_16359_18457# SUB sky130_fd_pr__nfet_01v8 ad=0.2226 pd=1.9 as=0.2226 ps=1.9 w=0.42 l=0.15
X187 a_34203_12295# x1 a_34067_12295# SUB sky130_fd_pr__nfet_01v8 ad=0.2226 pd=1.9 as=0.2226 ps=1.9 w=0.42 l=0.15
X188 a_2203_13804# x1 a_2067_13804# w_1991_13678# sky130_fd_pr__pfet_01v8 ad=0.8904 pd=4.42 as=0.8904 ps=4.42 w=1.68 l=0.15
X189 a_43379_19457# x2 a_43243_19457# SUB sky130_fd_pr__nfet_01v8 ad=0.4452 pd=2.74 as=0.4452 ps=2.74 w=0.84 l=0.15
X190 c1_23524_8500# x0 sky130_fd_pr__cap_mim_m3_1 l=4.8 w=38.4
.ends
