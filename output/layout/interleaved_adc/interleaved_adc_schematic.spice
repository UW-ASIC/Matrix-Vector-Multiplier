.subckt iadc_cdac_sw in_ out ctrl ctrl_b vdd vss
Xiadc_cdac_sw_n in_ ctrl out vss sky130_fd_pr__nfet_01v8 W=0.42 L=0.15
Xiadc_cdac_sw_p in_ ctrl_b out vdd sky130_fd_pr__pfet_01v8 W=0.84 L=0.15
.ends iadc_cdac_sw

.subckt iadc_cdac in0 in1 in2 in3 top_plate bottom_plate vdd vss
Xinv_n0 ctrl_b_0 in0 vss vss sky130_fd_pr__nfet_01v8 W=0.42 L=0.15
Xinv_p0 ctrl_b_0 in0 vdd vdd sky130_fd_pr__pfet_01v8 W=0.84 L=0.15
Xsw0 bottom_plate cap_bot_0 in0 ctrl_b_0 vdd vss iadc_cdac_sw
Xinv_n1 ctrl_b_1 in1 vss vss sky130_fd_pr__nfet_01v8 W=0.42 L=0.15
Xinv_p1 ctrl_b_1 in1 vdd vdd sky130_fd_pr__pfet_01v8 W=0.84 L=0.15
Xsw1 bottom_plate cap_bot_1 in1 ctrl_b_1 vdd vss iadc_cdac_sw
Xinv_n2 ctrl_b_2 in2 vss vss sky130_fd_pr__nfet_01v8 W=0.42 L=0.15
Xinv_p2 ctrl_b_2 in2 vdd vdd sky130_fd_pr__pfet_01v8 W=0.84 L=0.15
Xsw2 bottom_plate cap_bot_2 in2 ctrl_b_2 vdd vss iadc_cdac_sw
Xinv_n3 ctrl_b_3 in3 vss vss sky130_fd_pr__nfet_01v8 W=0.42 L=0.15
Xinv_p3 ctrl_b_3 in3 vdd vdd sky130_fd_pr__pfet_01v8 W=0.84 L=0.15
Xsw3 bottom_plate cap_bot_3 in3 ctrl_b_3 vdd vss iadc_cdac_sw
.ends iadc_cdac

.subckt iadc_mux_sw in_ out ctrl ctrl_b vdd vss
Xiadc_mux_sw_n in_ ctrl out vss sky130_fd_pr__nfet_01v8 W=0.42 L=0.15
Xiadc_mux_sw_p in_ ctrl_b out vdd sky130_fd_pr__pfet_01v8 W=1.42 L=0.15
.ends iadc_mux_sw

.subckt interleaved_adc col0 col1 col2 vref d0b0 d0b1 d0b2 d0b3 d1b0 d1b1 d1b2 d1b3 d2b0 d2b1 d2b2 d2b3 adc_go vdd vss
* ADC Unit 0: columns [0, 1]
Xu0_tail u0_tail adc_go vss vss sky130_fd_pr__nfet_01v8 W=0.42 L=0.15
Xu0_inp u0_drn_p u0_mux_out u0_tail vss sky130_fd_pr__nfet_01v8 W=7.0 L=0.15
Xu0_inn u0_drn_n u0_cdac_top u0_tail vss sky130_fd_pr__nfet_01v8 W=7.0 L=0.15
Xu0_xnp u0_outp u0_outn u0_drn_p vss sky130_fd_pr__nfet_01v8 W=1.0 L=0.15
Xu0_xnn u0_outn u0_outp u0_drn_n vss sky130_fd_pr__nfet_01v8 W=1.0 L=0.15
Xu0_xpp u0_outp u0_outn vdd vdd sky130_fd_pr__pfet_01v8 W=4.5 L=0.15
Xu0_xpn u0_outn u0_outp vdd vdd sky130_fd_pr__pfet_01v8 W=4.5 L=0.15
Xu0_rstp u0_outp adc_go vdd vdd sky130_fd_pr__pfet_01v8 W=1.0 L=0.15
Xu0_rstn u0_outn adc_go vdd vdd sky130_fd_pr__pfet_01v8 W=1.0 L=0.15
B_u0_mux u0_mux_out vss V = V(col0)
Xu0_cdac u0_sw0 u0_sw1 u0_sw2 u0_sw3 u0_cdac_top vref vdd vss iadc_cdac
B_u0_col0_b3 u0_col0_bit3 vss V = V(col0) >= V(vref) * 0.5 ? 1 : 0
B_u0_col0_dac3 u0_col0_dac3 vss V = V(u0_col0_bit3) * V(vref) * 0.5
B_u0_col0_b2 u0_col0_bit2 vss V = V(col0) >= V(u0_col0_dac3) + V(vref) * 0.25 ? 1 : 0
B_u0_col0_dac2 u0_col0_dac2 vss V = V(u0_col0_dac3) + V(u0_col0_bit2) * V(vref) * 0.25
B_u0_col0_b1 u0_col0_bit1 vss V = V(col0) >= V(u0_col0_dac2) + V(vref) * 0.125 ? 1 : 0
B_u0_col0_dac1 u0_col0_dac1 vss V = V(u0_col0_dac2) + V(u0_col0_bit1) * V(vref) * 0.125
B_u0_col0_b0 u0_col0_bit0 vss V = V(col0) >= V(u0_col0_dac1) + V(vref) * 0.0625 ? 1 : 0
B_u0_col0_dac0 u0_col0_dac0 vss V = V(u0_col0_dac1) + V(u0_col0_bit0) * V(vref) * 0.0625
B_u0_col0_sw0 u0_sw0 vss V = V(u0_col0_bit0) > 0.5 ? V(vdd) : 0
B_u0_col0_sw1 u0_sw1 vss V = V(u0_col0_bit1) > 0.5 ? V(vdd) : 0
B_u0_col0_sw2 u0_sw2 vss V = V(u0_col0_bit2) > 0.5 ? V(vdd) : 0
B_u0_col0_sw3 u0_sw3 vss V = V(u0_col0_bit3) > 0.5 ? V(vdd) : 0
B_u0_col0_d0 d0b0 vss V = V(u0_col0_bit0) > 0.5 ? V(vdd) : 0
B_u0_col0_d1 d0b1 vss V = V(u0_col0_bit1) > 0.5 ? V(vdd) : 0
B_u0_col0_d2 d0b2 vss V = V(u0_col0_bit2) > 0.5 ? V(vdd) : 0
B_u0_col0_d3 d0b3 vss V = V(u0_col0_bit3) > 0.5 ? V(vdd) : 0
B_u0_col1_b3 u0_col1_bit3 vss V = V(col1) >= V(vref) * 0.5 ? 1 : 0
B_u0_col1_dac3 u0_col1_dac3 vss V = V(u0_col1_bit3) * V(vref) * 0.5
B_u0_col1_b2 u0_col1_bit2 vss V = V(col1) >= V(u0_col1_dac3) + V(vref) * 0.25 ? 1 : 0
B_u0_col1_dac2 u0_col1_dac2 vss V = V(u0_col1_dac3) + V(u0_col1_bit2) * V(vref) * 0.25
B_u0_col1_b1 u0_col1_bit1 vss V = V(col1) >= V(u0_col1_dac2) + V(vref) * 0.125 ? 1 : 0
B_u0_col1_dac1 u0_col1_dac1 vss V = V(u0_col1_dac2) + V(u0_col1_bit1) * V(vref) * 0.125
B_u0_col1_b0 u0_col1_bit0 vss V = V(col1) >= V(u0_col1_dac1) + V(vref) * 0.0625 ? 1 : 0
B_u0_col1_dac0 u0_col1_dac0 vss V = V(u0_col1_dac1) + V(u0_col1_bit0) * V(vref) * 0.0625
B_u0_col1_d0 d1b0 vss V = V(u0_col1_bit0) > 0.5 ? V(vdd) : 0
B_u0_col1_d1 d1b1 vss V = V(u0_col1_bit1) > 0.5 ? V(vdd) : 0
B_u0_col1_d2 d1b2 vss V = V(u0_col1_bit2) > 0.5 ? V(vdd) : 0
B_u0_col1_d3 d1b3 vss V = V(u0_col1_bit3) > 0.5 ? V(vdd) : 0
* ADC Unit 1: columns [2]
Xu1_tail u1_tail adc_go vss vss sky130_fd_pr__nfet_01v8 W=0.42 L=0.15
Xu1_inp u1_drn_p u1_mux_out u1_tail vss sky130_fd_pr__nfet_01v8 W=7.0 L=0.15
Xu1_inn u1_drn_n u1_cdac_top u1_tail vss sky130_fd_pr__nfet_01v8 W=7.0 L=0.15
Xu1_xnp u1_outp u1_outn u1_drn_p vss sky130_fd_pr__nfet_01v8 W=1.0 L=0.15
Xu1_xnn u1_outn u1_outp u1_drn_n vss sky130_fd_pr__nfet_01v8 W=1.0 L=0.15
Xu1_xpp u1_outp u1_outn vdd vdd sky130_fd_pr__pfet_01v8 W=4.5 L=0.15
Xu1_xpn u1_outn u1_outp vdd vdd sky130_fd_pr__pfet_01v8 W=4.5 L=0.15
Xu1_rstp u1_outp adc_go vdd vdd sky130_fd_pr__pfet_01v8 W=1.0 L=0.15
Xu1_rstn u1_outn adc_go vdd vdd sky130_fd_pr__pfet_01v8 W=1.0 L=0.15
B_u1_mux u1_mux_out vss V = V(col2)
Xu1_cdac u1_sw0 u1_sw1 u1_sw2 u1_sw3 u1_cdac_top vref vdd vss iadc_cdac
B_u1_col2_b3 u1_col2_bit3 vss V = V(col2) >= V(vref) * 0.5 ? 1 : 0
B_u1_col2_dac3 u1_col2_dac3 vss V = V(u1_col2_bit3) * V(vref) * 0.5
B_u1_col2_b2 u1_col2_bit2 vss V = V(col2) >= V(u1_col2_dac3) + V(vref) * 0.25 ? 1 : 0
B_u1_col2_dac2 u1_col2_dac2 vss V = V(u1_col2_dac3) + V(u1_col2_bit2) * V(vref) * 0.25
B_u1_col2_b1 u1_col2_bit1 vss V = V(col2) >= V(u1_col2_dac2) + V(vref) * 0.125 ? 1 : 0
B_u1_col2_dac1 u1_col2_dac1 vss V = V(u1_col2_dac2) + V(u1_col2_bit1) * V(vref) * 0.125
B_u1_col2_b0 u1_col2_bit0 vss V = V(col2) >= V(u1_col2_dac1) + V(vref) * 0.0625 ? 1 : 0
B_u1_col2_dac0 u1_col2_dac0 vss V = V(u1_col2_dac1) + V(u1_col2_bit0) * V(vref) * 0.0625
B_u1_col2_sw0 u1_sw0 vss V = V(u1_col2_bit0) > 0.5 ? V(vdd) : 0
B_u1_col2_sw1 u1_sw1 vss V = V(u1_col2_bit1) > 0.5 ? V(vdd) : 0
B_u1_col2_sw2 u1_sw2 vss V = V(u1_col2_bit2) > 0.5 ? V(vdd) : 0
B_u1_col2_sw3 u1_sw3 vss V = V(u1_col2_bit3) > 0.5 ? V(vdd) : 0
B_u1_col2_d0 d2b0 vss V = V(u1_col2_bit0) > 0.5 ? V(vdd) : 0
B_u1_col2_d1 d2b1 vss V = V(u1_col2_bit1) > 0.5 ? V(vdd) : 0
B_u1_col2_d2 d2b2 vss V = V(u1_col2_bit2) > 0.5 ? V(vdd) : 0
B_u1_col2_d3 d2b3 vss V = V(u1_col2_bit3) > 0.5 ? V(vdd) : 0
.ends interleaved_adc
