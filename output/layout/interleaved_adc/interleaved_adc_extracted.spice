* NGSPICE file created from interleaved_adc_flat.ext - technology: sky130A

.subckt interleaved_adc_flat COL0 COL1 COL2 ADC_GO VREF D0B0 D0B1 D0B2 D0B3 D1B0 D1B1
+ D1B2 D1B3 D2B0 D2B1 D2B2 D2B3 VSS
X0 a_n653_n1064# a_2089_12453# a_n653_n1064# w_1925_11979# sky130_fd_pr__pfet_01v8 ad=0.7526 pd=3.9 as=578.28162 ps=834.15997 w=1.42 l=0.15
X1 adc_unit_1_0.D3 a_27383_106# a_27295_n42# a_n653_n1064# sky130_fd_pr__nfet_01v8 ad=0.2226 pd=1.9 as=0.2226 ps=1.9 w=0.42 l=0.15
X2 a_25527_10109# a_25527_10109# a_25527_10109# w_25723_10717# sky130_fd_pr__pfet_01v8 ad=0.1325 pd=1.03 as=3.5775 ps=24.1 w=0.5 l=0.15
X3 a_6862_n42# a_6814_106# a_6726_n42# a_n653_n1064# sky130_fd_pr__nfet_01v8 ad=0.2226 pd=1.9 as=0.2226 ps=1.9 w=0.42 l=0.15
X4 adc_unit_0_0.D1 a_2317_106# a_2229_n42# a_n653_n1064# sky130_fd_pr__nfet_01v8 ad=0.2226 pd=1.9 as=0.2226 ps=1.9 w=0.42 l=0.15
X5 m3_22816_7052# m3_22338_5206# sky130_fd_pr__cap_mim_m3_1 l=5 w=5
X6 adc_unit_1_0.D4 a_28630_106# a_n653_n1064# w_28466_302# sky130_fd_pr__pfet_01v8 ad=0.4452 pd=2.74 as=282.55289 ps=377.38 w=0.84 l=0.15
X7 a_n653_n1064# a_24555_11783# a_n653_n1064# a_n653_n1064# sky130_fd_pr__nfet_01v8 ad=0.2226 pd=1.9 as=3.816 ps=31.36 w=0.42 l=0.15
X8 a_23591_8691# a_n653_n1064# a_23591_8691# a_n653_n1064# sky130_fd_pr__nfet_01v8 ad=0.23055 pd=1.4 as=4.1499 ps=25.2 w=0.87 l=0.15
X9 a_1547_n42# a_1547_n42# a_1547_n512# a_n653_n1064# sky130_fd_pr__nfet_01v8 ad=0.2226 pd=1.9 as=0.2226 ps=1.9 w=0.42 l=0.15
X10 adc_unit_1_0.D7 a_32530_106# a_32442_n42# a_n653_n1064# sky130_fd_pr__nfet_01v8 ad=0.2226 pd=1.9 as=0.2226 ps=1.9 w=0.42 l=0.15
X11 a_n653_n1064# a_25755_12453# a_n653_n1064# w_25591_11979# sky130_fd_pr__pfet_01v8 ad=0.7526 pd=3.9 as=0 ps=0 w=1.42 l=0.15
X12 a_n653_n1064# a_n653_n1064# a_n653_n1064# w_1657_10717# sky130_fd_pr__pfet_01v8 ad=0.265 pd=2.06 as=0 ps=0 w=0.5 l=0.15
X13 a_25527_10109# a_25527_10109# a_25527_10109# a_n653_n1064# sky130_fd_pr__nfet_01v8 ad=0.1325 pd=1.03 as=0.795 ps=6.18 w=0.5 l=0.15
X14 m3_22816_7052# m3_23606_5206# sky130_fd_pr__cap_mim_m3_1 l=5 w=5
X15 a_29328_n42# a_29280_106# a_29192_n42# a_n653_n1064# sky130_fd_pr__nfet_01v8 ad=0.2226 pd=1.9 as=0.2226 ps=1.9 w=0.42 l=0.15
X16 VREF m3_32032_390# sky130_fd_pr__cap_mim_m3_1 l=3 w=3
X17 a_26781_n42# a_26637_n364# a_26637_n364# a_n653_n1064# sky130_fd_pr__nfet_01v8 ad=0.2226 pd=1.9 as=0.1113 ps=0.95 w=0.42 l=0.15
X18 a_1547_n42# a_1547_n42# a_1547_n42# a_n653_n1064# sky130_fd_pr__nfet_01v8 ad=0.1113 pd=0.95 as=0.6678 ps=5.7 w=0.42 l=0.15
X19 a_25067_8060# a_25067_8060# a_25067_8060# a_n653_n1064# sky130_fd_pr__nfet_01v8 ad=0.23055 pd=1.4 as=4.5951 ps=29 w=0.87 l=0.15
X20 a_28028_n42# a_27980_106# a_27892_428# w_27816_302# sky130_fd_pr__pfet_01v8 ad=0.4452 pd=2.74 as=0.4452 ps=2.74 w=0.84 l=0.15
X21 m3_22816_7052# m3_24874_5206# sky130_fd_pr__cap_mim_m3_1 l=5 w=5
X22 a_n653_n1064# a_n653_n1064# a_n653_n1064# w_1385_9983# sky130_fd_pr__pfet_01v8 ad=0.19875 pd=1.28 as=0 ps=0 w=0.75 l=0.15
X23 a_22881_n512# a_22833_n364# a_22745_n42# w_22669_n168# sky130_fd_pr__pfet_01v8 ad=0.2136 pd=1.9 as=0.2136 ps=1.9 w=0.425 l=0.15
X24 a_n653_n1064# a_n653_n1064# a_n653_n1064# w_23851_9983# sky130_fd_pr__pfet_01v8 ad=0.19875 pd=1.28 as=0 ps=0 w=0.75 l=0.15
X25 a_25067_8060# a_25067_8060# a_25067_8060# a_n653_n1064# sky130_fd_pr__nfet_01v8 ad=0.23055 pd=1.4 as=0 ps=0 w=0.87 l=0.15
X26 a_9462_n42# a_9414_106# a_9326_428# w_9250_302# sky130_fd_pr__pfet_01v8 ad=0.4452 pd=2.74 as=0.4452 ps=2.74 w=0.84 l=0.15
X27 a_n653_n1064# a_n653_n1064# a_n653_n1064# w_23851_9983# sky130_fd_pr__pfet_01v8 ad=0.3975 pd=2.56 as=0 ps=0 w=0.75 l=0.15
X28 a_25417_788# a_25369_1606# a_25281_788# w_25205_1132# sky130_fd_pr__pfet_01v8 ad=0.7526 pd=3.9 as=0.7526 ps=3.9 w=1.42 l=0.15
X29 m3_22816_7052# m3_26142_1402# sky130_fd_pr__cap_mim_m3_1 l=5 w=5
X30 a_31928_n42# a_31880_106# a_31792_n42# a_n653_n1064# sky130_fd_pr__nfet_01v8 ad=0.2226 pd=1.9 as=0.2226 ps=1.9 w=0.42 l=0.15
X31 a_1125_8691# a_n653_n1064# a_1125_8691# a_n653_n1064# sky130_fd_pr__nfet_01v8 ad=0.23055 pd=1.4 as=4.1499 ps=25.2 w=0.87 l=0.15
X32 a_2601_8060# a_2601_8060# a_2601_8060# a_n653_n1064# sky130_fd_pr__nfet_01v8 ad=0.23055 pd=1.4 as=4.5951 ps=29 w=0.87 l=0.15
X33 adc_unit_0_0.D7 a_10064_106# a_9976_n42# a_n653_n1064# sky130_fd_pr__nfet_01v8 ad=0.2226 pd=1.9 as=0.2226 ps=1.9 w=0.42 l=0.15
X34 m3_350_7052# m3_n128_2670# sky130_fd_pr__cap_mim_m3_1 l=5 w=5
X35 a_25527_10109# a_25527_10109# a_25527_10109# a_n653_n1064# sky130_fd_pr__nfet_01v8 ad=0.265 pd=2.06 as=0 ps=0 w=0.5 l=0.15
X36 a_26685_788# a_26637_936# a_26549_788# a_n653_n1064# sky130_fd_pr__nfet_01v8 ad=0.2226 pd=1.9 as=0.2226 ps=1.9 w=0.42 l=0.15
X37 adc_unit_1_0.D2 a_26083_106# a_25995_n42# a_n653_n1064# sky130_fd_pr__nfet_01v8 ad=0.2226 pd=1.9 as=0.2226 ps=1.9 w=0.42 l=0.15
X38 a_5562_n42# a_5514_106# a_5426_n42# a_n653_n1064# sky130_fd_pr__nfet_01v8 ad=0.2226 pd=1.9 as=0.2226 ps=1.9 w=0.42 l=0.15
X39 adc_unit_0_0.D0 a_1017_106# a_929_n42# a_n653_n1064# sky130_fd_pr__nfet_01v8 ad=0.2226 pd=1.9 as=0.2226 ps=1.9 w=0.42 l=0.15
X40 a_4171_n364# a_4171_n364# a_4083_n42# w_4007_n168# sky130_fd_pr__pfet_01v8 ad=0.0648 pd=0.75 as=0.4242 ps=2.74 w=0.42 l=0.15
X41 adc_unit_1_0.D1 a_24783_106# a_24695_428# w_24619_302# sky130_fd_pr__pfet_01v8 ad=0.4452 pd=2.74 as=0.4452 ps=2.74 w=0.84 l=0.15
X42 a_4315_n42# a_4171_n364# a_4179_428# w_4103_302# sky130_fd_pr__pfet_01v8 ad=0.4452 pd=2.74 as=0.4452 ps=2.74 w=0.84 l=0.15
X43 adc_unit_0_0.D6 a_8764_106# a_8676_428# w_8600_302# sky130_fd_pr__pfet_01v8 ad=0.4452 pd=2.74 as=0.4452 ps=2.74 w=0.84 l=0.15
X44 a_25067_8060# a_25067_8060# a_25067_8060# a_n653_n1064# sky130_fd_pr__nfet_01v8 ad=0.4611 pd=2.8 as=0 ps=0 w=0.87 l=0.15
X45 adc_unit_1_0.D6 a_31230_106# a_31142_n42# a_n653_n1064# sky130_fd_pr__nfet_01v8 ad=0.2226 pd=1.9 as=0.2226 ps=1.9 w=0.42 l=0.15
X46 a_n653_n1064# a_n653_n1064# a_n653_n1064# w_1657_10717# sky130_fd_pr__pfet_01v8 ad=0.1325 pd=1.03 as=0 ps=0 w=0.5 l=0.15
X47 a_25417_n512# a_25417_n512# a_25281_n42# a_n653_n1064# sky130_fd_pr__nfet_01v8 ad=0.2226 pd=1.9 as=0.1113 ps=0.95 w=0.42 l=0.15
X48 adc_unit_1_0.D5 a_29930_106# a_29842_n42# a_n653_n1064# sky130_fd_pr__nfet_01v8 ad=0.2226 pd=1.9 as=0.2226 ps=1.9 w=0.42 l=0.15
X49 a_415_n512# a_367_n364# a_279_n42# w_203_n168# sky130_fd_pr__pfet_01v8 ad=0.2136 pd=1.9 as=0.2136 ps=1.9 w=0.425 l=0.15
X50 a_8162_n42# a_8114_106# a_8026_428# w_7950_302# sky130_fd_pr__pfet_01v8 ad=0.4452 pd=2.74 as=0.4452 ps=2.74 w=0.84 l=0.15
X51 a_30628_n42# a_30580_106# a_30492_n42# a_n653_n1064# sky130_fd_pr__nfet_01v8 ad=0.2226 pd=1.9 as=0.2226 ps=1.9 w=0.42 l=0.15
X52 a_n653_n1064# a_24555_12453# a_n653_n1064# w_24391_11979# sky130_fd_pr__pfet_01v8 ad=0.7526 pd=3.9 as=0 ps=0 w=1.42 l=0.15
X53 a_25417_42# a_25281_n42# a_25281_n42# w_25205_n168# sky130_fd_pr__pfet_01v8 ad=0.0312 pd=0.59 as=0.357 ps=2.74 w=0.42 l=0.15
X54 a_n653_n1064# a_n653_n1064# a_n653_n1064# a_n653_n1064# sky130_fd_pr__nfet_01v8 ad=0.1325 pd=1.03 as=0 ps=0 w=0.5 l=0.15
X55 a_23591_8691# a_n653_n1064# a_23591_8691# a_n653_n1064# sky130_fd_pr__nfet_01v8 ad=0.23055 pd=1.4 as=0 ps=0 w=0.87 l=0.15
X56 m3_22816_7052# m3_22338_2670# sky130_fd_pr__cap_mim_m3_1 l=5 w=5
X57 a_24149_788# a_24101_1606# a_24013_788# w_23937_1132# sky130_fd_pr__pfet_01v8 ad=0.7526 pd=3.9 as=0.7526 ps=3.9 w=1.42 l=0.15
X58 a_25527_10109# a_25527_10109# a_25527_10109# w_25451_9983# sky130_fd_pr__pfet_01v8 ad=0.19875 pd=1.28 as=0 ps=0 w=0.75 l=0.15
X59 a_23591_8691# a_n653_n1064# a_23591_8691# a_n653_n1064# sky130_fd_pr__nfet_01v8 ad=0.23055 pd=1.4 as=0 ps=0 w=0.87 l=0.15
X60 a_3015_42# a_2951_n512# a_2951_42# w_2739_n168# sky130_fd_pr__pfet_01v8 ad=0.0792 pd=1.26 as=0.0312 ps=0.59 w=0.405 l=0.15
X61 a_1125_8691# a_n653_n1064# a_1125_8691# a_n653_n1064# sky130_fd_pr__nfet_01v8 ad=0.23055 pd=1.4 as=0 ps=0 w=0.87 l=0.15
X62 a_4219_788# a_4171_1606# a_4083_788# w_4007_1132# sky130_fd_pr__pfet_01v8 ad=0.7526 pd=3.9 as=0.7526 ps=3.9 w=1.42 l=0.15
X63 m3_22816_7052# m3_23606_2670# sky130_fd_pr__cap_mim_m3_1 l=5 w=5
X64 adc_unit_1_0.D0 a_23483_106# a_23395_428# w_23319_302# sky130_fd_pr__pfet_01v8 ad=0.4452 pd=2.74 as=0.4452 ps=2.74 w=0.84 l=0.15
X65 m3_350_7052# m3_1140_3938# sky130_fd_pr__cap_mim_m3_1 l=5 w=5
X66 a_3061_10109# a_3061_10109# a_3061_10109# a_n653_n1064# sky130_fd_pr__nfet_01v8 ad=0.1325 pd=1.03 as=0.795 ps=6.18 w=0.5 l=0.15
X67 adc_unit_0_0.D5 a_7464_106# a_7376_428# w_7300_302# sky130_fd_pr__pfet_01v8 ad=0.4452 pd=2.74 as=0.4452 ps=2.74 w=0.84 l=0.15
X68 m3_350_7052# m3_n128_1402# sky130_fd_pr__cap_mim_m3_1 l=5 w=5
X69 m3_22816_7052# m3_24874_2670# sky130_fd_pr__cap_mim_m3_1 l=5 w=5
X70 m3_350_7052# m3_2408_3938# sky130_fd_pr__cap_mim_m3_1 l=5 w=5
X71 a_24013_n42# a_24013_n42# a_24013_n42# a_n653_n1064# sky130_fd_pr__nfet_01v8 ad=0.1113 pd=0.95 as=0.6678 ps=5.7 w=0.42 l=0.15
X72 a_2601_8060# a_2601_8060# a_2601_8060# a_n653_n1064# sky130_fd_pr__nfet_01v8 ad=0.23055 pd=1.4 as=0 ps=0 w=0.87 l=0.15
X73 a_n653_n1064# a_n653_n1064# a_n653_n1064# w_1385_9983# sky130_fd_pr__pfet_01v8 ad=0.19875 pd=1.28 as=0 ps=0 w=0.75 l=0.15
X74 a_2601_8060# a_2601_8060# a_2601_8060# a_n653_n1064# sky130_fd_pr__nfet_01v8 ad=0.23055 pd=1.4 as=0 ps=0 w=0.87 l=0.15
X75 adc_unit_0_0.D3 a_4917_106# a_4829_428# w_4753_302# sky130_fd_pr__pfet_01v8 ad=0.4452 pd=2.74 as=0.4452 ps=2.74 w=0.84 l=0.15
X76 VREF m3_n606_390# sky130_fd_pr__cap_mim_m3_1 l=3 w=3
X77 a_23591_8691# a_n653_n1064# a_23591_8691# a_n653_n1064# sky130_fd_pr__nfet_01v8 ad=0.4611 pd=2.8 as=0 ps=0 w=0.87 l=0.15
X78 a_22881_n512# a_22833_n364# a_22745_428# w_22669_302# sky130_fd_pr__pfet_01v8 ad=0.4452 pd=2.74 as=0.4452 ps=2.74 w=0.84 l=0.15
X79 m3_350_7052# m3_3676_3938# sky130_fd_pr__cap_mim_m3_1 l=5 w=5
X80 a_3061_10109# a_3061_10109# a_3061_10109# w_3257_10717# sky130_fd_pr__pfet_01v8 ad=0.265 pd=2.06 as=3.5775 ps=24.1 w=0.5 l=0.15
X81 a_2951_788# a_2903_1606# a_2815_788# w_2739_1132# sky130_fd_pr__pfet_01v8 ad=0.7526 pd=3.9 as=0.7526 ps=3.9 w=1.42 l=0.15
X82 a_25417_n512# a_25281_n42# a_25281_n512# a_n653_n1064# sky130_fd_pr__nfet_01v8 ad=0.2226 pd=1.9 as=0.2226 ps=1.9 w=0.42 l=0.15
X83 adc_unit_1_0.D4 a_28630_106# a_n653_n1064# a_n653_n1064# sky130_fd_pr__nfet_01v8 ad=0.2226 pd=1.9 as=0.2226 ps=1.9 w=0.42 l=0.15
X84 a_3061_10109# a_3061_10109# a_3061_10109# w_2985_9983# sky130_fd_pr__pfet_01v8 ad=0.19875 pd=1.28 as=0 ps=0 w=0.75 l=0.15
X85 a_25527_10109# a_25527_10109# a_25527_10109# w_25451_9983# sky130_fd_pr__pfet_01v8 ad=0.19875 pd=1.28 as=0 ps=0 w=0.75 l=0.15
X86 a_3061_10109# a_3061_10109# a_3061_10109# w_2985_9983# sky130_fd_pr__pfet_01v8 ad=0.19875 pd=1.28 as=0 ps=0 w=0.75 l=0.15
X87 a_25527_10109# a_25527_10109# a_25527_10109# w_25451_9983# sky130_fd_pr__pfet_01v8 ad=0.19875 pd=1.28 as=0 ps=0 w=0.75 l=0.15
X88 a_25067_8060# a_25067_8060# a_25067_8060# a_n653_n1064# sky130_fd_pr__nfet_01v8 ad=0.23055 pd=1.4 as=0 ps=0 w=0.87 l=0.15
X89 a_26781_42# a_26637_n364# a_26637_n364# w_26473_n168# sky130_fd_pr__pfet_01v8 ad=0.016 pd=0.74 as=0.0648 ps=0.75 w=0.405 l=0.15
X90 a_28028_n42# a_27980_106# a_27892_n42# a_n653_n1064# sky130_fd_pr__nfet_01v8 ad=0.2226 pd=1.9 as=0.2226 ps=1.9 w=0.42 l=0.15
X91 a_1683_42# a_1547_n42# a_1547_n42# w_1471_n168# sky130_fd_pr__pfet_01v8 ad=3.2m pd=0.66 as=0.2898 ps=2.74 w=0.795 l=0.15
X92 a_2601_8060# a_2601_8060# a_2601_8060# a_n653_n1064# sky130_fd_pr__nfet_01v8 ad=0.23055 pd=1.4 as=0 ps=0 w=0.87 l=0.15
X93 adc_unit_0_0.D4 a_6164_106# a_n653_n1064# w_6000_302# sky130_fd_pr__pfet_01v8 ad=0.4452 pd=2.74 as=282.55289 ps=377.38 w=0.84 l=0.15
X94 m3_350_7052# m3_1140_5206# sky130_fd_pr__cap_mim_m3_1 l=5 w=5
X95 a_2601_8060# ADC_GO a_2601_8060# a_n653_n1064# sky130_fd_pr__nfet_01v8 ad=0.2226 pd=1.9 as=0 ps=0 w=0.42 l=0.15
X96 a_25067_8060# ADC_GO a_25067_8060# a_n653_n1064# sky130_fd_pr__nfet_01v8 ad=0.2226 pd=1.9 as=0 ps=0 w=0.42 l=0.15
X97 m3_22816_7052# m3_22338_1402# sky130_fd_pr__cap_mim_m3_1 l=5 w=5
X98 a_9462_n42# a_9414_106# a_9326_n42# a_n653_n1064# sky130_fd_pr__nfet_01v8 ad=0.2226 pd=1.9 as=0.2226 ps=1.9 w=0.42 l=0.15
X99 a_n653_n1064# a_n653_n1064# a_n653_n1064# w_1385_9983# sky130_fd_pr__pfet_01v8 ad=0.19875 pd=1.28 as=0 ps=0 w=0.75 l=0.15
X100 m3_350_7052# m3_2408_5206# sky130_fd_pr__cap_mim_m3_1 l=5 w=5
X101 a_n653_n1064# a_n653_n1064# a_n653_n1064# w_23851_9983# sky130_fd_pr__pfet_01v8 ad=0.19875 pd=1.28 as=0 ps=0 w=0.75 l=0.15
X102 m3_22816_7052# m3_23606_1402# sky130_fd_pr__cap_mim_m3_1 l=5 w=5
X103 a_n653_n1064# a_n653_n1064# a_n653_n1064# w_23851_9983# sky130_fd_pr__pfet_01v8 ad=0.19875 pd=1.28 as=0 ps=0 w=0.75 l=0.15
X104 adc_unit_0_0.D2 a_3617_106# a_3529_428# w_3453_302# sky130_fd_pr__pfet_01v8 ad=0.4452 pd=2.74 as=0.4452 ps=2.74 w=0.84 l=0.15
X105 a_3061_10109# a_3061_10109# a_3061_10109# w_3257_10717# sky130_fd_pr__pfet_01v8 ad=0.1325 pd=1.03 as=0 ps=0 w=0.5 l=0.15
X106 a_415_n512# a_367_n364# a_279_428# w_203_302# sky130_fd_pr__pfet_01v8 ad=0.4452 pd=2.74 as=0.4452 ps=2.74 w=0.84 l=0.15
X107 a_25067_8060# a_25067_8060# a_25067_8060# a_n653_n1064# sky130_fd_pr__nfet_01v8 ad=0.23055 pd=1.4 as=0 ps=0 w=0.87 l=0.15
X108 m3_22816_7052# m3_26142_3938# sky130_fd_pr__cap_mim_m3_1 l=5 w=5
X109 m3_350_7052# m3_3676_5206# sky130_fd_pr__cap_mim_m3_1 l=5 w=5
X110 a_n653_n1064# a_n653_n1064# a_n653_n1064# a_n653_n1064# sky130_fd_pr__nfet_01v8 ad=0.1325 pd=1.03 as=0 ps=0 w=0.5 l=0.15
X111 a_25067_8060# a_25067_8060# a_25067_8060# a_n653_n1064# sky130_fd_pr__nfet_01v8 ad=0.23055 pd=1.4 as=0 ps=0 w=0.87 l=0.15
X112 m3_22816_7052# m3_24874_1402# sky130_fd_pr__cap_mim_m3_1 l=5 w=5
X113 adc_unit_1_0.D1 a_24783_106# a_24695_n42# a_n653_n1064# sky130_fd_pr__nfet_01v8 ad=0.2226 pd=1.9 as=0.2226 ps=1.9 w=0.42 l=0.15
X114 a_24013_n42# a_24013_n42# a_24013_n512# a_n653_n1064# sky130_fd_pr__nfet_01v8 ad=0.2226 pd=1.9 as=0.2226 ps=1.9 w=0.42 l=0.15
X115 adc_unit_0_0.D6 a_8764_106# a_8676_n42# a_n653_n1064# sky130_fd_pr__nfet_01v8 ad=0.2226 pd=1.9 as=0.2226 ps=1.9 w=0.42 l=0.15
X116 a_1125_8691# a_n653_n1064# a_1125_8691# a_n653_n1064# sky130_fd_pr__nfet_01v8 ad=0.23055 pd=1.4 as=0 ps=0 w=0.87 l=0.15
X117 a_1125_8691# a_n653_n1064# a_1125_8691# a_n653_n1064# sky130_fd_pr__nfet_01v8 ad=0.23055 pd=1.4 as=0 ps=0 w=0.87 l=0.15
X118 a_1683_788# a_1635_936# a_1547_788# a_n653_n1064# sky130_fd_pr__nfet_01v8 ad=0.2226 pd=1.9 as=0.2226 ps=1.9 w=0.42 l=0.15
X119 a_4315_n42# a_4171_n364# a_4171_n364# a_n653_n1064# sky130_fd_pr__nfet_01v8 ad=0.2226 pd=1.9 as=0.1113 ps=0.95 w=0.42 l=0.15
X120 a_n653_n1064# a_n653_n1064# a_n653_n1064# w_24123_10717# sky130_fd_pr__pfet_01v8 ad=0.265 pd=2.06 as=0 ps=0 w=0.5 l=0.15
X121 a_25527_10109# a_25527_10109# a_25527_10109# w_25451_9983# sky130_fd_pr__pfet_01v8 ad=0.3975 pd=2.56 as=0 ps=0 w=0.75 l=0.15
X122 a_n653_n1064# a_3289_11783# a_n653_n1064# a_n653_n1064# sky130_fd_pr__nfet_01v8 ad=0.2226 pd=1.9 as=0 ps=0 w=0.42 l=0.15
X123 a_4171_n364# a_4171_n364# a_4083_n512# a_n653_n1064# sky130_fd_pr__nfet_01v8 ad=0.2226 pd=1.9 as=0.2226 ps=1.9 w=0.42 l=0.15
X124 a_415_788# a_367_1606# a_279_788# w_203_1132# sky130_fd_pr__pfet_01v8 ad=0.7526 pd=3.9 as=0.7526 ps=3.9 w=1.42 l=0.15
X125 a_2951_n512# a_2951_n512# a_2879_428# w_2803_302# sky130_fd_pr__pfet_01v8 ad=0.4452 pd=2.74 as=0.4452 ps=2.74 w=0.84 l=0.15
X126 a_25481_42# a_25417_n512# a_25417_42# w_25205_n168# sky130_fd_pr__pfet_01v8 ad=0.0792 pd=1.26 as=0.0312 ps=0.59 w=0.405 l=0.15
X127 a_22881_788# a_22833_1606# a_22745_788# w_22669_1132# sky130_fd_pr__pfet_01v8 ad=0.7526 pd=3.9 as=0.7526 ps=3.9 w=1.42 l=0.15
X128 a_4219_788# a_4171_936# a_4083_788# a_n653_n1064# sky130_fd_pr__nfet_01v8 ad=0.2226 pd=1.9 as=0.2226 ps=1.9 w=0.42 l=0.15
X129 a_23591_8691# a_n653_n1064# a_23591_8691# a_n653_n1064# sky130_fd_pr__nfet_01v8 ad=0.23055 pd=1.4 as=0 ps=0 w=0.87 l=0.15
X130 a_8162_n42# a_8114_106# a_8026_n42# a_n653_n1064# sky130_fd_pr__nfet_01v8 ad=0.2226 pd=1.9 as=0.2226 ps=1.9 w=0.42 l=0.15
X131 a_n653_n1064# a_n653_n1064# a_n653_n1064# w_1385_9983# sky130_fd_pr__pfet_01v8 ad=0.19875 pd=1.28 as=0 ps=0 w=0.75 l=0.15
X132 a_n653_n1064# a_n653_n1064# a_n653_n1064# w_1385_9983# sky130_fd_pr__pfet_01v8 ad=0.3975 pd=2.56 as=0 ps=0 w=0.75 l=0.15
X133 a_1125_8691# a_n653_n1064# a_1125_8691# a_n653_n1064# sky130_fd_pr__nfet_01v8 ad=0.23055 pd=1.4 as=0 ps=0 w=0.87 l=0.15
X134 a_6862_n42# a_6814_106# a_6726_428# w_6650_302# sky130_fd_pr__pfet_01v8 ad=0.4452 pd=2.74 as=0.4452 ps=2.74 w=0.84 l=0.15
X135 adc_unit_1_0.D3 a_27383_106# a_27295_428# w_27219_302# sky130_fd_pr__pfet_01v8 ad=0.4452 pd=2.74 as=0.4452 ps=2.74 w=0.84 l=0.15
X136 adc_unit_0_0.D1 a_2317_106# a_2229_428# w_2153_302# sky130_fd_pr__pfet_01v8 ad=0.4452 pd=2.74 as=0.4452 ps=2.74 w=0.84 l=0.15
X137 a_2951_n512# a_2815_n42# a_2815_n512# a_n653_n1064# sky130_fd_pr__nfet_01v8 ad=0.2226 pd=1.9 as=0.2226 ps=1.9 w=0.42 l=0.15
X138 m3_22816_7052# m3_26142_5206# sky130_fd_pr__cap_mim_m3_1 l=5 w=5
X139 adc_unit_1_0.D0 a_23483_106# a_23395_n42# a_n653_n1064# sky130_fd_pr__nfet_01v8 ad=0.2226 pd=1.9 as=0.2226 ps=1.9 w=0.42 l=0.15
X140 adc_unit_0_0.D5 a_7464_106# a_7376_n42# a_n653_n1064# sky130_fd_pr__nfet_01v8 ad=0.2226 pd=1.9 as=0.2226 ps=1.9 w=0.42 l=0.15
X141 a_n653_n1064# a_n653_n1064# a_n653_n1064# w_24123_10717# sky130_fd_pr__pfet_01v8 ad=0.1325 pd=1.03 as=0 ps=0 w=0.5 l=0.15
X142 a_n653_n1064# a_n653_n1064# a_n653_n1064# a_n653_n1064# sky130_fd_pr__nfet_01v8 ad=0.265 pd=2.06 as=0 ps=0 w=0.5 l=0.15
X143 adc_unit_1_0.D7 a_32530_106# a_32442_428# w_32366_302# sky130_fd_pr__pfet_01v8 ad=0.4452 pd=2.74 as=0.4452 ps=2.74 w=0.84 l=0.15
X144 a_2601_8060# a_2601_8060# a_2601_8060# a_n653_n1064# sky130_fd_pr__nfet_01v8 ad=0.23055 pd=1.4 as=0 ps=0 w=0.87 l=0.15
X145 a_29328_n42# a_29280_106# a_29192_428# w_29116_302# sky130_fd_pr__pfet_01v8 ad=0.4452 pd=2.74 as=0.4452 ps=2.74 w=0.84 l=0.15
X146 a_23591_8691# a_n653_n1064# a_23591_8691# a_n653_n1064# sky130_fd_pr__nfet_01v8 ad=0.23055 pd=1.4 as=0 ps=0 w=0.87 l=0.15
X147 m3_350_7052# m3_1140_2670# sky130_fd_pr__cap_mim_m3_1 l=5 w=5
X148 a_26781_n42# a_26637_n364# a_26645_428# w_26569_302# sky130_fd_pr__pfet_01v8 ad=0.4452 pd=2.74 as=0.4452 ps=2.74 w=0.84 l=0.15
X149 a_23591_8691# a_n653_n1064# a_23591_8691# a_n653_n1064# sky130_fd_pr__nfet_01v8 ad=0.23055 pd=1.4 as=0 ps=0 w=0.87 l=0.15
X150 a_26685_788# a_26637_1606# a_26549_788# w_26473_1132# sky130_fd_pr__pfet_01v8 ad=0.7526 pd=3.9 as=0.7526 ps=3.9 w=1.42 l=0.15
X151 a_1547_n42# a_1547_n42# a_1579_428# w_1503_302# sky130_fd_pr__pfet_01v8 ad=0.4452 pd=2.74 as=0.4452 ps=2.74 w=0.84 l=0.15
X152 adc_unit_0_0.D3 a_4917_106# a_4829_n42# a_n653_n1064# sky130_fd_pr__nfet_01v8 ad=0.2226 pd=1.9 as=0.2226 ps=1.9 w=0.42 l=0.15
X153 a_3061_10109# a_3061_10109# a_3061_10109# a_n653_n1064# sky130_fd_pr__nfet_01v8 ad=0.265 pd=2.06 as=0 ps=0 w=0.5 l=0.15
X154 m3_350_7052# m3_2408_2670# sky130_fd_pr__cap_mim_m3_1 l=5 w=5
X155 a_26637_n364# a_26637_n364# a_26549_n42# w_26473_n168# sky130_fd_pr__pfet_01v8 ad=0.0648 pd=0.75 as=0.4242 ps=2.74 w=0.42 l=0.15
X156 a_22881_n512# a_22833_n364# a_22745_n42# a_n653_n1064# sky130_fd_pr__nfet_01v8 ad=0.2226 pd=1.9 as=0.2226 ps=1.9 w=0.42 l=0.15
X157 m3_350_7052# m3_n128_3938# sky130_fd_pr__cap_mim_m3_1 l=5 w=5
X158 adc_unit_0_0.D7 a_10064_106# a_9976_428# w_9900_302# sky130_fd_pr__pfet_01v8 ad=0.4452 pd=2.74 as=0.4452 ps=2.74 w=0.84 l=0.15
X159 a_24149_42# a_24013_n42# a_24013_n42# w_23937_n168# sky130_fd_pr__pfet_01v8 ad=3.2m pd=0.66 as=0.2898 ps=2.74 w=0.795 l=0.15
X160 a_31928_n42# a_31880_106# a_31792_428# w_31716_302# sky130_fd_pr__pfet_01v8 ad=0.4452 pd=2.74 as=0.4452 ps=2.74 w=0.84 l=0.15
X161 a_n653_n1064# a_2089_11783# a_n653_n1064# a_n653_n1064# sky130_fd_pr__nfet_01v8 ad=0.2226 pd=1.9 as=0 ps=0 w=0.42 l=0.15
X162 a_25067_8060# a_25067_8060# a_25067_8060# a_n653_n1064# sky130_fd_pr__nfet_01v8 ad=0.23055 pd=1.4 as=0 ps=0 w=0.87 l=0.15
X163 m3_350_7052# m3_3676_2670# sky130_fd_pr__cap_mim_m3_1 l=5 w=5
X164 a_2601_8060# a_2601_8060# a_2601_8060# a_n653_n1064# sky130_fd_pr__nfet_01v8 ad=0.23055 pd=1.4 as=0 ps=0 w=0.87 l=0.15
X165 a_5562_n42# a_5514_106# a_5426_428# w_5350_302# sky130_fd_pr__pfet_01v8 ad=0.4452 pd=2.74 as=0.4452 ps=2.74 w=0.84 l=0.15
X166 adc_unit_1_0.D2 a_26083_106# a_25995_428# w_25919_302# sky130_fd_pr__pfet_01v8 ad=0.4452 pd=2.74 as=0.4452 ps=2.74 w=0.84 l=0.15
X167 adc_unit_0_0.D0 a_1017_106# a_929_428# w_853_302# sky130_fd_pr__pfet_01v8 ad=0.4452 pd=2.74 as=0.4452 ps=2.74 w=0.84 l=0.15
X168 a_n653_n1064# a_3289_12453# a_n653_n1064# w_3125_11979# sky130_fd_pr__pfet_01v8 ad=0.7526 pd=3.9 as=0 ps=0 w=1.42 l=0.15
X169 a_3061_10109# a_3061_10109# a_3061_10109# w_2985_9983# sky130_fd_pr__pfet_01v8 ad=0.19875 pd=1.28 as=0 ps=0 w=0.75 l=0.15
X170 a_1683_788# a_1635_1606# a_1547_788# w_1471_1132# sky130_fd_pr__pfet_01v8 ad=0.7526 pd=3.9 as=0.7526 ps=3.9 w=1.42 l=0.15
X171 a_2601_8060# a_2601_8060# a_2601_8060# a_n653_n1064# sky130_fd_pr__nfet_01v8 ad=0.4611 pd=2.8 as=0 ps=0 w=0.87 l=0.15
X172 a_22881_788# a_22833_936# a_22745_788# a_n653_n1064# sky130_fd_pr__nfet_01v8 ad=0.2226 pd=1.9 as=0.2226 ps=1.9 w=0.42 l=0.15
X173 a_3061_10109# a_3061_10109# a_3061_10109# w_2985_9983# sky130_fd_pr__pfet_01v8 ad=0.19875 pd=1.28 as=0 ps=0 w=0.75 l=0.15
X174 a_25527_10109# a_25527_10109# a_25527_10109# w_25451_9983# sky130_fd_pr__pfet_01v8 ad=0.19875 pd=1.28 as=0 ps=0 w=0.75 l=0.15
X175 a_2951_788# a_2903_936# a_2815_788# a_n653_n1064# sky130_fd_pr__nfet_01v8 ad=0.2226 pd=1.9 as=0.2226 ps=1.9 w=0.42 l=0.15
X176 adc_unit_0_0.D4 a_6164_106# a_n653_n1064# a_n653_n1064# sky130_fd_pr__nfet_01v8 ad=0.2226 pd=1.9 as=0.2226 ps=1.9 w=0.42 l=0.15
X177 a_n653_n1064# a_25755_11783# a_n653_n1064# a_n653_n1064# sky130_fd_pr__nfet_01v8 ad=0.2226 pd=1.9 as=0 ps=0 w=0.42 l=0.15
X178 adc_unit_1_0.D6 a_31230_106# a_31142_428# w_31066_302# sky130_fd_pr__pfet_01v8 ad=0.4452 pd=2.74 as=0.4452 ps=2.74 w=0.84 l=0.15
X179 a_415_n512# a_367_n364# a_279_n512# a_n653_n1064# sky130_fd_pr__nfet_01v8 ad=0.2226 pd=1.9 as=0.2226 ps=1.9 w=0.42 l=0.15
X180 a_25417_n512# a_25417_n512# a_25345_428# w_25269_302# sky130_fd_pr__pfet_01v8 ad=0.4452 pd=2.74 as=0.4452 ps=2.74 w=0.84 l=0.15
X181 a_25067_8060# a_25067_8060# a_25067_8060# a_n653_n1064# sky130_fd_pr__nfet_01v8 ad=0.23055 pd=1.4 as=0 ps=0 w=0.87 l=0.15
X182 a_24149_788# a_24101_936# a_24013_788# a_n653_n1064# sky130_fd_pr__nfet_01v8 ad=0.2226 pd=1.9 as=0.2226 ps=1.9 w=0.42 l=0.15
X183 a_22881_n512# a_22833_n364# a_22745_n512# a_n653_n1064# sky130_fd_pr__nfet_01v8 ad=0.2226 pd=1.9 as=0.2226 ps=1.9 w=0.42 l=0.15
X184 adc_unit_0_0.D2 a_3617_106# a_3529_n42# a_n653_n1064# sky130_fd_pr__nfet_01v8 ad=0.2226 pd=1.9 as=0.2226 ps=1.9 w=0.42 l=0.15
X185 a_25417_788# a_25369_936# a_25281_788# a_n653_n1064# sky130_fd_pr__nfet_01v8 ad=0.2226 pd=1.9 as=0.2226 ps=1.9 w=0.42 l=0.15
X186 a_1125_8691# a_n653_n1064# a_1125_8691# a_n653_n1064# sky130_fd_pr__nfet_01v8 ad=0.23055 pd=1.4 as=0 ps=0 w=0.87 l=0.15
X187 m3_22816_7052# m3_22338_3938# sky130_fd_pr__cap_mim_m3_1 l=5 w=5
X188 a_415_n512# a_367_n364# a_279_n42# a_n653_n1064# sky130_fd_pr__nfet_01v8 ad=0.2226 pd=1.9 as=0.2226 ps=1.9 w=0.42 l=0.15
X189 adc_unit_1_0.D5 a_29930_106# a_29842_428# w_29766_302# sky130_fd_pr__pfet_01v8 ad=0.4452 pd=2.74 as=0.4452 ps=2.74 w=0.84 l=0.15
X190 m3_350_7052# m3_n128_5206# sky130_fd_pr__cap_mim_m3_1 l=5 w=5
X191 m3_350_7052# m3_1140_1402# sky130_fd_pr__cap_mim_m3_1 l=5 w=5
X192 a_30628_n42# a_30580_106# a_30492_428# w_30416_302# sky130_fd_pr__pfet_01v8 ad=0.4452 pd=2.74 as=0.4452 ps=2.74 w=0.84 l=0.15
X193 a_4315_42# a_4171_n364# a_4171_n364# w_4007_n168# sky130_fd_pr__pfet_01v8 ad=0.016 pd=0.74 as=0.0648 ps=0.75 w=0.405 l=0.15
X194 m3_22816_7052# m3_26142_2670# sky130_fd_pr__cap_mim_m3_1 l=5 w=5
X195 m3_22816_7052# m3_23606_3938# sky130_fd_pr__cap_mim_m3_1 l=5 w=5
X196 a_2951_42# a_2815_n42# a_2815_n42# w_2739_n168# sky130_fd_pr__pfet_01v8 ad=0.0312 pd=0.59 as=0.357 ps=2.74 w=0.42 l=0.15
X197 m3_350_7052# m3_2408_1402# sky130_fd_pr__cap_mim_m3_1 l=5 w=5
X198 a_25527_10109# a_25527_10109# a_25527_10109# w_25451_9983# sky130_fd_pr__pfet_01v8 ad=0.19875 pd=1.28 as=0 ps=0 w=0.75 l=0.15
X199 a_2951_n512# a_2951_n512# a_2815_n42# a_n653_n1064# sky130_fd_pr__nfet_01v8 ad=0.2226 pd=1.9 as=0.1113 ps=0.95 w=0.42 l=0.15
X200 a_3061_10109# a_3061_10109# a_3061_10109# w_2985_9983# sky130_fd_pr__pfet_01v8 ad=0.19875 pd=1.28 as=0 ps=0 w=0.75 l=0.15
X201 a_n653_n1064# a_n653_n1064# a_n653_n1064# a_n653_n1064# sky130_fd_pr__nfet_01v8 ad=0.265 pd=2.06 as=0 ps=0 w=0.5 l=0.15
X202 a_2601_8060# a_2601_8060# a_2601_8060# a_n653_n1064# sky130_fd_pr__nfet_01v8 ad=0.23055 pd=1.4 as=0 ps=0 w=0.87 l=0.15
X203 a_415_788# a_367_936# a_279_788# a_n653_n1064# sky130_fd_pr__nfet_01v8 ad=0.2226 pd=1.9 as=0.2226 ps=1.9 w=0.42 l=0.15
X204 a_23591_8691# a_n653_n1064# a_23591_8691# a_n653_n1064# sky130_fd_pr__nfet_01v8 ad=0.23055 pd=1.4 as=0 ps=0 w=0.87 l=0.15
X205 m3_22816_7052# m3_24874_3938# sky130_fd_pr__cap_mim_m3_1 l=5 w=5
X206 a_3061_10109# a_3061_10109# a_3061_10109# w_2985_9983# sky130_fd_pr__pfet_01v8 ad=0.3975 pd=2.56 as=0 ps=0 w=0.75 l=0.15
X207 a_1125_8691# a_n653_n1064# a_1125_8691# a_n653_n1064# sky130_fd_pr__nfet_01v8 ad=0.23055 pd=1.4 as=0 ps=0 w=0.87 l=0.15
X208 m3_350_7052# m3_3676_1402# sky130_fd_pr__cap_mim_m3_1 l=5 w=5
X209 a_n653_n1064# a_n653_n1064# a_n653_n1064# w_23851_9983# sky130_fd_pr__pfet_01v8 ad=0.19875 pd=1.28 as=0 ps=0 w=0.75 l=0.15
X210 a_26637_n364# a_26637_n364# a_26549_n512# a_n653_n1064# sky130_fd_pr__nfet_01v8 ad=0.2226 pd=1.9 as=0.2226 ps=1.9 w=0.42 l=0.15
X211 a_n653_n1064# a_n653_n1064# a_n653_n1064# w_23851_9983# sky130_fd_pr__pfet_01v8 ad=0.19875 pd=1.28 as=0 ps=0 w=0.75 l=0.15
X212 a_n653_n1064# a_n653_n1064# a_n653_n1064# w_1385_9983# sky130_fd_pr__pfet_01v8 ad=0.19875 pd=1.28 as=0 ps=0 w=0.75 l=0.15
X213 a_1125_8691# a_n653_n1064# a_1125_8691# a_n653_n1064# sky130_fd_pr__nfet_01v8 ad=0.4611 pd=2.8 as=0 ps=0 w=0.87 l=0.15
X214 a_25527_10109# a_25527_10109# a_25527_10109# w_25723_10717# sky130_fd_pr__pfet_01v8 ad=0.265 pd=2.06 as=0 ps=0 w=0.5 l=0.15
X215 a_24013_n42# a_24013_n42# a_24045_428# w_23969_302# sky130_fd_pr__pfet_01v8 ad=0.4452 pd=2.74 as=0.4452 ps=2.74 w=0.84 l=0.15
.ends
