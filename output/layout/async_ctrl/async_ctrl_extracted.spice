* NGSPICE file created from async_ctrl_flat.ext - technology: sky130A

.subckt async_ctrl_flat GO
X0 a_9001_1848# GO a_8865_1848# a_n530_n509# sky130_fd_pr__nfet_01v8 ad=0.2226 pd=1.9 as=0.2226 ps=1.9 w=0.42 l=0.15
X1 GO GO GO w_14134_3070# sky130_fd_pr__pfet_01v8 ad=0.4452 pd=2.74 as=43.1632 ps=266.76001 w=0.84 l=0.15
X2 GO GO GO w_8710_910# sky130_fd_pr__pfet_01v8 ad=0.4452 pd=2.74 as=0 ps=0 w=0.84 l=0.15
X3 a_2801_1848# GO a_2665_1848# a_n530_n509# sky130_fd_pr__nfet_01v8 ad=0.2226 pd=1.9 as=0.2226 ps=1.9 w=0.42 l=0.15
X4 GO GO a_6189_2388# a_n530_n509# sky130_fd_pr__nfet_01v8 ad=0.952 pd=7.36 as=0.952 ps=7.36 w=3.4 l=5.6
X5 GO GO a_13165_1252# a_n530_n509# sky130_fd_pr__nfet_01v8 ad=0.952 pd=7.36 as=0.952 ps=7.36 w=3.4 l=5.6
X6 GO GO a_9289_4548# a_n530_n509# sky130_fd_pr__nfet_01v8 ad=0.952 pd=7.36 as=0.952 ps=7.36 w=3.4 l=5.6
X7 GO GO a_9289_5572# a_n530_n509# sky130_fd_pr__nfet_01v8 ad=0.952 pd=7.36 as=0.952 ps=7.36 w=3.4 l=5.6
X8 GO GO a_15489_3412# a_n530_n509# sky130_fd_pr__nfet_01v8 ad=0.952 pd=7.36 as=0.952 ps=7.36 w=3.4 l=5.6
X9 GO GO GO w_1010_910# sky130_fd_pr__pfet_01v8 ad=0.4452 pd=2.74 as=0 ps=0 w=0.84 l=0.15
X10 a_3625_2388# GO a_3489_2388# a_n530_n509# sky130_fd_pr__nfet_01v8 ad=0.2226 pd=1.9 as=0.2226 ps=1.9 w=0.42 l=0.15
X11 GO GO GO w_2050_7390# sky130_fd_pr__pfet_01v8 ad=0.4452 pd=2.74 as=0 ps=0 w=0.84 l=0.15
X12 GO GO GO w_17234_5230# sky130_fd_pr__pfet_01v8 ad=0.4452 pd=2.74 as=0 ps=0 w=0.84 l=0.15
X13 a_15201_1848# GO a_15065_1848# a_n530_n509# sky130_fd_pr__nfet_01v8 ad=0.2226 pd=1.9 as=0.2226 ps=1.9 w=0.42 l=0.15
X14 a_5125_2388# GO a_4989_2388# a_n530_n509# sky130_fd_pr__nfet_01v8 ad=0.2226 pd=1.9 as=0.2226 ps=1.9 w=0.42 l=0.15
X15 GO GO GO w_11034_5230# sky130_fd_pr__pfet_01v8 ad=0.4452 pd=2.74 as=0 ps=0 w=0.84 l=0.15
X16 a_15201_228# GO a_15065_228# a_n530_n509# sky130_fd_pr__nfet_01v8 ad=0.2226 pd=1.9 as=0.2226 ps=1.9 w=0.42 l=0.15
X17 a_8225_4548# GO a_8089_4548# a_n530_n509# sky130_fd_pr__nfet_01v8 ad=0.2226 pd=1.9 as=0.2226 ps=1.9 w=0.42 l=0.15
X18 a_2341_6708# GO a_2205_6708# a_n530_n509# sky130_fd_pr__nfet_01v8 ad=0.2226 pd=1.9 as=0.2226 ps=1.9 w=0.42 l=0.15
X19 GO GO GO w_7934_3070# sky130_fd_pr__pfet_01v8 ad=0.4452 pd=2.74 as=0 ps=0 w=0.84 l=0.15
X20 GO GO GO w_2700_2872# sky130_fd_pr__pfet_01v8 ad=0.4452 pd=2.74 as=0 ps=0 w=0.84 l=0.15
X21 GO GO GO w_n30_3070# sky130_fd_pr__pfet_01v8 ad=0.4452 pd=2.74 as=0 ps=0 w=0.84 l=0.15
X22 a_12101_228# GO a_11965_228# a_n530_n509# sky130_fd_pr__nfet_01v8 ad=0.2226 pd=1.9 as=0.2226 ps=1.9 w=0.42 l=0.15
X23 a_17525_4008# GO a_17389_4008# a_n530_n509# sky130_fd_pr__nfet_01v8 ad=0.2226 pd=1.9 as=0.2226 ps=1.9 w=0.42 l=0.15
X24 a_5125_6168# GO a_4989_6168# a_n530_n509# sky130_fd_pr__nfet_01v8 ad=0.2226 pd=1.9 as=0.2226 ps=1.9 w=0.42 l=0.15
X25 a_261_228# GO a_125_228# a_n530_n509# sky130_fd_pr__nfet_01v8 ad=0.2226 pd=1.9 as=0.2226 ps=1.9 w=0.42 l=0.15
X26 a_11325_4008# GO a_11189_4008# a_n530_n509# sky130_fd_pr__nfet_01v8 ad=0.2226 pd=1.9 as=0.2226 ps=1.9 w=0.42 l=0.15
X27 GO GO GO w_17234_5230# sky130_fd_pr__pfet_01v8 ad=0.4452 pd=2.74 as=0 ps=0 w=0.84 l=0.15
X28 GO GO GO w_11034_5230# sky130_fd_pr__pfet_01v8 ad=0.4452 pd=2.74 as=0 ps=0 w=0.84 l=0.15
X29 GO GO GO w_7934_3070# sky130_fd_pr__pfet_01v8 ad=0.4452 pd=2.74 as=0 ps=0 w=0.84 l=0.15
X30 GO GO GO w_4590_7390# sky130_fd_pr__pfet_01v8 ad=0.4452 pd=2.74 as=0 ps=0 w=0.84 l=0.15
X31 GO GO a_2725_2388# a_n530_n509# sky130_fd_pr__nfet_01v8 ad=0.4452 pd=2.74 as=0.4452 ps=2.74 w=0.84 l=0.15
X32 GO GO GO w_1010_3070# sky130_fd_pr__pfet_01v8 ad=0.4452 pd=2.74 as=0 ps=0 w=0.84 l=0.15
X33 a_5921_6708# GO a_5785_6708# a_n530_n509# sky130_fd_pr__nfet_01v8 ad=0.2226 pd=1.9 as=0.2226 ps=1.9 w=0.42 l=0.15
X34 a_1301_228# GO a_1165_228# a_n530_n509# sky130_fd_pr__nfet_01v8 ad=0.2226 pd=1.9 as=0.2226 ps=1.9 w=0.42 l=0.15
X35 a_261_2388# GO a_125_2388# a_n530_n509# sky130_fd_pr__nfet_01v8 ad=0.2226 pd=1.9 as=0.2226 ps=1.9 w=0.42 l=0.15
X36 GO GO a_6965_1252# a_n530_n509# sky130_fd_pr__nfet_01v8 ad=0.952 pd=7.36 as=0.952 ps=7.36 w=3.4 l=5.6
X37 GO GO a_9289_3412# a_n530_n509# sky130_fd_pr__nfet_01v8 ad=0.952 pd=7.36 as=0.952 ps=7.36 w=3.4 l=5.6
X38 GO GO GO w_n30_7390# sky130_fd_pr__pfet_01v8 ad=0.4452 pd=2.74 as=0 ps=0 w=0.84 l=0.15
X39 GO GO GO w_10360_7192# sky130_fd_pr__pfet_01v8 ad=0.265 pd=2.06 as=0 ps=0 w=0.5 l=0.15
X40 GO GO a_15489_2388# a_n530_n509# sky130_fd_pr__nfet_01v8 ad=0.952 pd=7.36 as=0.952 ps=7.36 w=3.4 l=5.6
X41 GO GO GO w_5610_910# sky130_fd_pr__pfet_01v8 ad=0.4452 pd=2.74 as=0 ps=0 w=0.84 l=0.15
X42 GO GO a_18589_4548# a_n530_n509# sky130_fd_pr__nfet_01v8 ad=0.952 pd=7.36 as=0.952 ps=7.36 w=3.4 l=5.6
X43 GO GO GO w_2510_910# sky130_fd_pr__pfet_01v8 ad=0.4452 pd=2.74 as=0 ps=0 w=0.84 l=0.15
X44 GO GO a_18589_5572# a_n530_n509# sky130_fd_pr__nfet_01v8 ad=0.952 pd=7.36 as=0.952 ps=7.36 w=3.4 l=5.6
X45 GO GO GO w_2510_910# sky130_fd_pr__pfet_01v8 ad=0.4452 pd=2.74 as=0 ps=0 w=0.84 l=0.15
X46 a_261_6708# GO a_125_6708# a_n530_n509# sky130_fd_pr__nfet_01v8 ad=0.2226 pd=1.9 as=0.2226 ps=1.9 w=0.42 l=0.15
X47 GO GO a_12389_4548# a_n530_n509# sky130_fd_pr__nfet_01v8 ad=0.952 pd=7.36 as=0.952 ps=7.36 w=3.4 l=5.6
X48 GO GO GO w_4834_5230# sky130_fd_pr__pfet_01v8 ad=0.4452 pd=2.74 as=0 ps=0 w=0.84 l=0.15
X49 GO GO a_12389_5572# a_n530_n509# sky130_fd_pr__nfet_01v8 ad=0.952 pd=7.36 as=0.952 ps=7.36 w=3.4 l=5.6
X50 GO GO GO w_2050_3070# sky130_fd_pr__pfet_01v8 ad=0.4452 pd=2.74 as=0 ps=0 w=0.84 l=0.15
X51 a_14425_2388# GO a_14289_2388# a_n530_n509# sky130_fd_pr__nfet_01v8 ad=0.2226 pd=1.9 as=0.2226 ps=1.9 w=0.42 l=0.15
X52 GO GO GO w_1010_7390# sky130_fd_pr__pfet_01v8 ad=0.4452 pd=2.74 as=0 ps=0 w=0.84 l=0.15
X53 GO a_10973_6856# a_10885_6708# a_n530_n509# sky130_fd_pr__nfet_01v8 ad=0.2226 pd=1.9 as=0.2226 ps=1.9 w=0.42 l=0.15
X54 a_17525_4548# GO a_17389_4548# a_n530_n509# sky130_fd_pr__nfet_01v8 ad=0.2226 pd=1.9 as=0.2226 ps=1.9 w=0.42 l=0.15
X55 GO GO GO w_14910_910# sky130_fd_pr__pfet_01v8 ad=0.4452 pd=2.74 as=0 ps=0 w=0.84 l=0.15
X56 GO GO GO w_10860_7192# sky130_fd_pr__pfet_01v8 ad=0.2226 pd=1.9 as=0 ps=0 w=0.42 l=0.15
X57 GO GO GO w_17234_3070# sky130_fd_pr__pfet_01v8 ad=0.4452 pd=2.74 as=0 ps=0 w=0.84 l=0.15
X58 a_5125_4008# GO a_4989_4008# a_n530_n509# sky130_fd_pr__nfet_01v8 ad=0.2226 pd=1.9 as=0.2226 ps=1.9 w=0.42 l=0.15
X59 a_11325_4548# GO a_11189_4548# a_n530_n509# sky130_fd_pr__nfet_01v8 ad=0.2226 pd=1.9 as=0.2226 ps=1.9 w=0.42 l=0.15
X60 a_8001_6708# GO a_7865_6708# a_n530_n509# sky130_fd_pr__nfet_01v8 ad=0.2226 pd=1.9 as=0.2226 ps=1.9 w=0.42 l=0.15
X61 GO GO GO w_4834_5230# sky130_fd_pr__pfet_01v8 ad=0.4452 pd=2.74 as=0 ps=0 w=0.84 l=0.15
X62 GO GO GO w_11034_3070# sky130_fd_pr__pfet_01v8 ad=0.4452 pd=2.74 as=0 ps=0 w=0.84 l=0.15
X63 GO GO a_3865_1252# a_n530_n509# sky130_fd_pr__nfet_01v8 ad=0.952 pd=7.36 as=0.952 ps=7.36 w=3.4 l=5.6
X64 a_14425_6168# GO a_14289_6168# a_n530_n509# sky130_fd_pr__nfet_01v8 ad=0.2226 pd=1.9 as=0.2226 ps=1.9 w=0.42 l=0.15
X65 a_9001_228# GO a_8865_228# a_n530_n509# sky130_fd_pr__nfet_01v8 ad=0.2226 pd=1.9 as=0.2226 ps=1.9 w=0.42 l=0.15
X66 a_2361_2388# GO a_2225_2388# a_n530_n509# sky130_fd_pr__nfet_01v8 ad=0.4452 pd=2.74 as=0.4452 ps=2.74 w=0.84 l=0.15
X67 GO GO GO w_7710_7390# sky130_fd_pr__pfet_01v8 ad=0.4452 pd=2.74 as=0 ps=0 w=0.84 l=0.15
X68 a_5901_228# GO a_5765_228# a_n530_n509# sky130_fd_pr__nfet_01v8 ad=0.2226 pd=1.9 as=0.2226 ps=1.9 w=0.42 l=0.15
X69 GO GO GO w_17234_3070# sky130_fd_pr__pfet_01v8 ad=0.4452 pd=2.74 as=0 ps=0 w=0.84 l=0.15
X70 GO a_10024_7582# GO w_9860_7192# sky130_fd_pr__pfet_01v8 ad=0.53 pd=3.06 as=0 ps=0 w=1 l=0.15
X71 a_5901_1848# GO a_5765_1848# a_n530_n509# sky130_fd_pr__nfet_01v8 ad=0.2226 pd=1.9 as=0.2226 ps=1.9 w=0.42 l=0.15
X72 GO GO a_9289_2388# a_n530_n509# sky130_fd_pr__nfet_01v8 ad=0.952 pd=7.36 as=0.952 ps=7.36 w=3.4 l=5.6
X73 a_2801_228# GO a_2665_228# a_n530_n509# sky130_fd_pr__nfet_01v8 ad=0.2226 pd=1.9 as=0.2226 ps=1.9 w=0.42 l=0.15
X74 GO GO GO w_11034_3070# sky130_fd_pr__pfet_01v8 ad=0.4452 pd=2.74 as=0 ps=0 w=0.84 l=0.15
X75 GO GO a_16265_1252# a_n530_n509# sky130_fd_pr__nfet_01v8 ad=0.952 pd=7.36 as=0.952 ps=7.36 w=3.4 l=5.6
X76 GO GO a_18589_3412# a_n530_n509# sky130_fd_pr__nfet_01v8 ad=0.952 pd=7.36 as=0.952 ps=7.36 w=3.4 l=5.6
X77 GO GO GO w_3090_7390# sky130_fd_pr__pfet_01v8 ad=0.4452 pd=2.74 as=0 ps=0 w=0.84 l=0.15
X78 a_4881_6708# GO a_4745_6708# a_n530_n509# sky130_fd_pr__nfet_01v8 ad=0.2226 pd=1.9 as=0.2226 ps=1.9 w=0.42 l=0.15
X79 GO a_9524_7582# GO w_9210_7390# sky130_fd_pr__pfet_01v8 ad=0.53 pd=3.06 as=0 ps=0 w=1 l=0.15
X80 GO GO a_16265_228# a_n530_n509# sky130_fd_pr__nfet_01v8 ad=0.952 pd=7.36 as=0.952 ps=7.36 w=3.4 l=5.6
X81 GO GO a_10065_1252# a_n530_n509# sky130_fd_pr__nfet_01v8 ad=0.952 pd=7.36 as=0.952 ps=7.36 w=3.4 l=5.6
X82 GO GO a_6189_4548# a_n530_n509# sky130_fd_pr__nfet_01v8 ad=0.952 pd=7.36 as=0.952 ps=7.36 w=3.4 l=5.6
X83 GO GO a_6189_5572# a_n530_n509# sky130_fd_pr__nfet_01v8 ad=0.952 pd=7.36 as=0.952 ps=7.36 w=3.4 l=5.6
X84 GO GO a_12389_3412# a_n530_n509# sky130_fd_pr__nfet_01v8 ad=0.952 pd=7.36 as=0.952 ps=7.36 w=3.4 l=5.6
X85 a_10521_6708# a_10473_6856# a_10385_6708# a_n530_n509# sky130_fd_pr__nfet_01v8 ad=0.2226 pd=1.9 as=0.2226 ps=1.9 w=0.42 l=0.15
X86 a_8225_2388# GO a_8089_2388# a_n530_n509# sky130_fd_pr__nfet_01v8 ad=0.2226 pd=1.9 as=0.2226 ps=1.9 w=0.42 l=0.15
X87 GO GO a_13165_228# a_n530_n509# sky130_fd_pr__nfet_01v8 ad=0.952 pd=7.36 as=0.952 ps=7.36 w=3.4 l=5.6
X88 a_1301_2388# GO a_1165_2388# a_n530_n509# sky130_fd_pr__nfet_01v8 ad=0.2226 pd=1.9 as=0.2226 ps=1.9 w=0.42 l=0.15
X89 GO GO GO w_14134_5230# sky130_fd_pr__pfet_01v8 ad=0.4452 pd=2.74 as=0 ps=0 w=0.84 l=0.15
X90 GO GO a_10065_228# a_n530_n509# sky130_fd_pr__nfet_01v8 ad=0.952 pd=7.36 as=0.952 ps=7.36 w=3.4 l=5.6
X91 a_12101_1848# GO a_11965_1848# a_n530_n509# sky130_fd_pr__nfet_01v8 ad=0.2226 pd=1.9 as=0.2226 ps=1.9 w=0.42 l=0.15
X92 GO GO GO w_8710_910# sky130_fd_pr__pfet_01v8 ad=0.4452 pd=2.74 as=0 ps=0 w=0.84 l=0.15
X93 a_5125_4548# GO a_4989_4548# a_n530_n509# sky130_fd_pr__nfet_01v8 ad=0.2226 pd=1.9 as=0.2226 ps=1.9 w=0.42 l=0.15
X94 a_9385_6708# a_9973_6872# a_9385_6708# a_n530_n509# sky130_fd_pr__nfet_01v8 ad=0.265 pd=2.06 as=1.06 ps=8.24 w=0.5 l=0.15
X95 GO GO GO w_4834_3070# sky130_fd_pr__pfet_01v8 ad=0.4452 pd=2.74 as=0 ps=0 w=0.84 l=0.15
X96 GO GO GO w_6670_7390# sky130_fd_pr__pfet_01v8 ad=0.4452 pd=2.74 as=0 ps=0 w=0.84 l=0.15
X97 a_8225_6168# GO a_8089_6168# a_n530_n509# sky130_fd_pr__nfet_01v8 ad=0.2226 pd=1.9 as=0.2226 ps=1.9 w=0.42 l=0.15
X98 GO GO a_6965_228# a_n530_n509# sky130_fd_pr__nfet_01v8 ad=0.952 pd=7.36 as=0.952 ps=7.36 w=3.4 l=5.6
X99 a_14425_4008# GO a_14289_4008# a_n530_n509# sky130_fd_pr__nfet_01v8 ad=0.2226 pd=1.9 as=0.2226 ps=1.9 w=0.42 l=0.15
X100 a_1301_6708# GO a_1165_6708# a_n530_n509# sky130_fd_pr__nfet_01v8 ad=0.2226 pd=1.9 as=0.2226 ps=1.9 w=0.42 l=0.15
X101 GO GO GO w_14134_5230# sky130_fd_pr__pfet_01v8 ad=0.4452 pd=2.74 as=0 ps=0 w=0.84 l=0.15
X102 GO GO GO w_3334_3070# sky130_fd_pr__pfet_01v8 ad=0.4452 pd=2.74 as=0 ps=0 w=0.84 l=0.15
X103 a_6961_6708# GO a_6825_6708# a_n530_n509# sky130_fd_pr__nfet_01v8 ad=0.2226 pd=1.9 as=0.2226 ps=1.9 w=0.42 l=0.15
X104 GO GO GO w_n30_910# sky130_fd_pr__pfet_01v8 ad=0.4452 pd=2.74 as=0 ps=0 w=0.84 l=0.15
X105 GO GO GO w_4834_3070# sky130_fd_pr__pfet_01v8 ad=0.4452 pd=2.74 as=0 ps=0 w=0.84 l=0.15
X106 GO GO a_18589_2388# a_n530_n509# sky130_fd_pr__nfet_01v8 ad=0.952 pd=7.36 as=0.952 ps=7.36 w=3.4 l=5.6
X107 GO GO a_6189_3412# a_n530_n509# sky130_fd_pr__nfet_01v8 ad=0.952 pd=7.36 as=0.952 ps=7.36 w=3.4 l=5.6
X108 GO GO GO w_5610_910# sky130_fd_pr__pfet_01v8 ad=0.4452 pd=2.74 as=0 ps=0 w=0.84 l=0.15
X109 GO GO a_12389_2388# a_n530_n509# sky130_fd_pr__nfet_01v8 ad=0.952 pd=7.36 as=0.952 ps=7.36 w=3.4 l=5.6
X110 GO GO a_15489_4548# a_n530_n509# sky130_fd_pr__nfet_01v8 ad=0.952 pd=7.36 as=0.952 ps=7.36 w=3.4 l=5.6
X111 GO GO GO w_7934_5230# sky130_fd_pr__pfet_01v8 ad=0.4452 pd=2.74 as=0 ps=0 w=0.84 l=0.15
X112 GO GO a_15489_5572# a_n530_n509# sky130_fd_pr__nfet_01v8 ad=0.952 pd=7.36 as=0.952 ps=7.36 w=3.4 l=5.6
X113 a_3381_6708# GO a_3245_6708# a_n530_n509# sky130_fd_pr__nfet_01v8 ad=0.2226 pd=1.9 as=0.2226 ps=1.9 w=0.42 l=0.15
X114 a_17525_2388# GO a_17389_2388# a_n530_n509# sky130_fd_pr__nfet_01v8 ad=0.2226 pd=1.9 as=0.2226 ps=1.9 w=0.42 l=0.15
X115 a_9385_6708# a_9473_6872# a_9385_6708# a_n530_n509# sky130_fd_pr__nfet_01v8 ad=0.265 pd=2.06 as=0 ps=0 w=0.5 l=0.15
X116 a_11325_2388# GO a_11189_2388# a_n530_n509# sky130_fd_pr__nfet_01v8 ad=0.2226 pd=1.9 as=0.2226 ps=1.9 w=0.42 l=0.15
X117 a_8225_4008# GO a_8089_4008# a_n530_n509# sky130_fd_pr__nfet_01v8 ad=0.2226 pd=1.9 as=0.2226 ps=1.9 w=0.42 l=0.15
X118 a_14425_4548# GO a_14289_4548# a_n530_n509# sky130_fd_pr__nfet_01v8 ad=0.2226 pd=1.9 as=0.2226 ps=1.9 w=0.42 l=0.15
X119 GO GO GO w_11810_910# sky130_fd_pr__pfet_01v8 ad=0.4452 pd=2.74 as=0 ps=0 w=0.84 l=0.15
X120 GO GO GO w_7934_5230# sky130_fd_pr__pfet_01v8 ad=0.4452 pd=2.74 as=0 ps=0 w=0.84 l=0.15
X121 GO GO GO w_14134_3070# sky130_fd_pr__pfet_01v8 ad=0.4452 pd=2.74 as=0 ps=0 w=0.84 l=0.15
X122 GO GO GO w_14910_910# sky130_fd_pr__pfet_01v8 ad=0.4452 pd=2.74 as=0 ps=0 w=0.84 l=0.15
X123 a_17525_6168# GO a_17389_6168# a_n530_n509# sky130_fd_pr__nfet_01v8 ad=0.2226 pd=1.9 as=0.2226 ps=1.9 w=0.42 l=0.15
X124 GO GO GO w_5630_7390# sky130_fd_pr__pfet_01v8 ad=0.4452 pd=2.74 as=0 ps=0 w=0.84 l=0.15
X125 GO GO a_3865_228# a_n530_n509# sky130_fd_pr__nfet_01v8 ad=0.952 pd=7.36 as=0.952 ps=7.36 w=3.4 l=5.6
X126 GO GO GO w_11810_910# sky130_fd_pr__pfet_01v8 ad=0.4452 pd=2.74 as=0 ps=0 w=0.84 l=0.15
X127 a_11325_6168# GO a_11189_6168# a_n530_n509# sky130_fd_pr__nfet_01v8 ad=0.2226 pd=1.9 as=0.2226 ps=1.9 w=0.42 l=0.15
.ends
