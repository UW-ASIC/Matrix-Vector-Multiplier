.subckt sh_bank_sw in_ out ctrl ctrl_b vdd vss
Xsh_bank_sw_n in_ ctrl out vss sky130_fd_pr__nfet_01v8 W=0.84 L=0.15
Xsh_bank_sw_p in_ ctrl_b out vdd sky130_fd_pr__pfet_01v8 W=1.68 L=0.15
.ends sh_bank_sw

.subckt sample_hold_bank in0 in1 in2 out0 out1 out2 sh_ctrl vdd vss
Xinv_ctrl_n sh_ctrl_b sh_ctrl vss vss sky130_fd_pr__nfet_01v8 W=0.42 L=0.15
Xinv_ctrl_p sh_ctrl_b sh_ctrl vdd vdd sky130_fd_pr__pfet_01v8 W=0.84 L=0.15
Xsw0 in0 out0 sh_ctrl sh_ctrl_b vdd vss sh_bank_sw
Xsw1 in1 out1 sh_ctrl sh_ctrl_b vdd vss sh_bank_sw
Xsw2 in2 out2 sh_ctrl sh_ctrl_b vdd vss sh_bank_sw
.ends sample_hold_bank
