* NGSPICE file created from charge_dac_flat.ext - technology: sky130A

.subckt charge_dac_flat OUT B0 B1 B2 B3 VSS
X0 c1_1306_8294# a_2762_3364# sky130_fd_pr__cap_mim_m3_1 l=4.85 w=4.85
X1 VSS VSS VSS w_4877_1690# sky130_fd_pr__pfet_01v8 ad=0.4452 pd=2.74 as=3.5616 ps=21.92 w=0.84 l=0.15
X2 VSS VSS VSS w_6669_1690# sky130_fd_pr__pfet_01v8 ad=0.4452 pd=2.74 as=0 ps=0 w=0.84 l=0.15
X3 c1_3694_8294# a_2762_3364# sky130_fd_pr__cap_mim_m3_1 l=4.85 w=4.85
X4 c1_112_7100# a_2762_3364# sky130_fd_pr__cap_mim_m3_1 l=4.85 w=4.85
X5 c1_4888_9488# a_2762_3364# sky130_fd_pr__cap_mim_m3_1 l=4.85 w=4.85
X6 c1_4888_4712# a_2762_3364# sky130_fd_pr__cap_mim_m3_1 l=4.85 w=4.85
X7 c1_2500_10682# a_2762_3364# sky130_fd_pr__cap_mim_m3_1 l=4.85 w=4.85
X8 a_4689_2732# a_4641_3132# VSS SUB sky130_fd_pr__nfet_01v8 ad=0.8904 pd=4.42 as=0.8904 ps=4.42 w=1.68 l=0.15
X9 c1_1306_9488# a_2762_3364# sky130_fd_pr__cap_mim_m3_1 l=4.85 w=4.85
X10 c1_1306_4712# a_2762_3364# sky130_fd_pr__cap_mim_m3_1 l=4.85 w=4.85
X11 c1_112_8294# a_2762_3364# sky130_fd_pr__cap_mim_m3_1 l=4.85 w=4.85
X12 c1_3694_9488# a_2762_3364# sky130_fd_pr__cap_mim_m3_1 l=4.85 w=4.85
X13 c1_6082_7100# a_2762_3364# sky130_fd_pr__cap_mim_m3_1 l=4.85 w=4.85
X14 c1_3694_4712# a_2762_3364# sky130_fd_pr__cap_mim_m3_1 l=4.85 w=4.85
X15 a_1108_3364# a_1060_4100# a_972_3364# w_896_3238# sky130_fd_pr__pfet_01v8 ad=1.7808 pd=7.78 as=1.7808 ps=7.78 w=3.36 l=0.15
X16 c1_4888_5906# a_2762_3364# sky130_fd_pr__cap_mim_m3_1 l=4.85 w=4.85
X17 a_2762_3364# a_5441_4100# a_5353_3364# w_5277_3238# sky130_fd_pr__pfet_01v8 ad=1.7808 pd=7.78 as=1.7808 ps=7.78 w=3.36 l=0.15
X18 VSS VSS VSS w_1295_1690# sky130_fd_pr__pfet_01v8 ad=0.4452 pd=2.74 as=0 ps=0 w=0.84 l=0.15
X19 a_1908_3364# a_1860_4100# a_1772_3364# w_1696_3238# sky130_fd_pr__pfet_01v8 ad=1.7808 pd=7.78 as=1.7808 ps=7.78 w=3.36 l=0.15
X20 c1_1306_5906# a_2762_3364# sky130_fd_pr__cap_mim_m3_1 l=4.85 w=4.85
X21 VSS VSS VSS w_3087_1690# sky130_fd_pr__pfet_01v8 ad=0.4452 pd=2.74 as=0 ps=0 w=0.84 l=0.15
X22 c1_112_9488# a_2762_3364# sky130_fd_pr__cap_mim_m3_1 l=4.85 w=4.85
X23 c1_6082_8294# a_2762_3364# sky130_fd_pr__cap_mim_m3_1 l=4.85 w=4.85
X24 c1_112_4712# a_2762_3364# sky130_fd_pr__cap_mim_m3_1 l=4.85 w=4.85
X25 c1_112_10682# a_2762_3364# sky130_fd_pr__cap_mim_m3_1 l=4.85 w=4.85
X26 c1_2500_7100# a_2762_3364# sky130_fd_pr__cap_mim_m3_1 l=4.85 w=4.85
X27 c1_3694_5906# a_2762_3364# sky130_fd_pr__cap_mim_m3_1 l=4.85 w=4.85
X28 a_6480_3364# a_6432_4100# a_6344_3364# w_6268_3238# sky130_fd_pr__pfet_01v8 ad=1.7808 pd=7.78 as=1.7808 ps=7.78 w=3.36 l=0.15
X29 a_5089_1258# B2 a_4953_1258# SUB sky130_fd_pr__nfet_01v8 ad=0.2226 pd=1.9 as=0.2226 ps=1.9 w=0.42 l=0.15
X30 c1_1306_10682# a_2762_3364# sky130_fd_pr__cap_mim_m3_1 l=4.85 w=4.85
X31 c1_3694_10682# a_2762_3364# sky130_fd_pr__cap_mim_m3_1 l=4.85 w=4.85
X32 a_1108_2732# a_1060_3132# VSS SUB sky130_fd_pr__nfet_01v8 ad=0.8904 pd=4.42 as=0.8904 ps=4.42 w=1.68 l=0.15
X33 a_5489_2732# a_5441_3132# VSS SUB sky130_fd_pr__nfet_01v8 ad=0.8904 pd=4.42 as=0.8904 ps=4.42 w=1.68 l=0.15
X34 a_6881_1258# B3 a_6745_1258# SUB sky130_fd_pr__nfet_01v8 ad=0.2226 pd=1.9 as=0.2226 ps=1.9 w=0.42 l=0.15
X35 a_2762_3364# a_2850_4100# a_2762_3364# w_2686_3238# sky130_fd_pr__pfet_01v8 ad=1.7808 pd=7.78 as=10.6848 ps=46.68 w=3.36 l=0.15
X36 c1_2500_8294# a_2762_3364# sky130_fd_pr__cap_mim_m3_1 l=4.85 w=4.85
X37 a_1908_2732# a_1860_3132# VSS SUB sky130_fd_pr__nfet_01v8 ad=0.8904 pd=4.42 as=0.8904 ps=4.42 w=1.68 l=0.15
X38 c1_6082_9488# a_2762_3364# sky130_fd_pr__cap_mim_m3_1 l=4.85 w=4.85
X39 c1_112_5906# a_2762_3364# sky130_fd_pr__cap_mim_m3_1 l=4.85 w=4.85
X40 c1_6082_4712# a_2762_3364# sky130_fd_pr__cap_mim_m3_1 l=4.85 w=4.85
X41 a_7281_3364# a_7233_4100# a_7145_3364# w_7069_3238# sky130_fd_pr__pfet_01v8 ad=1.7808 pd=7.78 as=1.7808 ps=7.78 w=3.36 l=0.15
X42 a_2762_3364# a_3651_4100# a_2762_3364# w_3487_3238# sky130_fd_pr__pfet_01v8 ad=1.7808 pd=7.78 as=0 ps=0 w=3.36 l=0.15
X43 a_6480_2732# a_6432_3132# VSS SUB sky130_fd_pr__nfet_01v8 ad=0.8904 pd=4.42 as=0.8904 ps=4.42 w=1.68 l=0.15
X44 c1_2500_9488# a_2762_3364# sky130_fd_pr__cap_mim_m3_1 l=4.85 w=4.85
X45 c1_2500_4712# a_2762_3364# sky130_fd_pr__cap_mim_m3_1 l=4.85 w=4.85
X46 a_2898_2732# a_2850_3132# VSS SUB sky130_fd_pr__nfet_01v8 ad=0.8904 pd=4.42 as=0.8904 ps=4.42 w=1.68 l=0.15
X47 c1_4888_10682# a_2762_3364# sky130_fd_pr__cap_mim_m3_1 l=4.85 w=4.85
X48 c1_4888_7100# a_2762_3364# sky130_fd_pr__cap_mim_m3_1 l=4.85 w=4.85
X49 c1_6082_5906# a_2762_3364# sky130_fd_pr__cap_mim_m3_1 l=4.85 w=4.85
X50 a_1507_1258# B0 a_1371_1258# SUB sky130_fd_pr__nfet_01v8 ad=0.2226 pd=1.9 as=0.2226 ps=1.9 w=0.42 l=0.15
X51 c1_6082_10682# a_2762_3364# sky130_fd_pr__cap_mim_m3_1 l=4.85 w=4.85
X52 c1_1306_7100# a_2762_3364# sky130_fd_pr__cap_mim_m3_1 l=4.85 w=4.85
X53 a_7281_2732# a_7233_3132# VSS SUB sky130_fd_pr__nfet_01v8 ad=0.8904 pd=4.42 as=0.8904 ps=4.42 w=1.68 l=0.15
X54 a_2762_3364# a_4641_4100# a_4553_3364# w_4477_3238# sky130_fd_pr__pfet_01v8 ad=1.7808 pd=7.78 as=1.7808 ps=7.78 w=3.36 l=0.15
X55 a_3299_1258# B1 a_3163_1258# SUB sky130_fd_pr__nfet_01v8 ad=0.2226 pd=1.9 as=0.2226 ps=1.9 w=0.42 l=0.15
X56 c1_4888_8294# a_2762_3364# sky130_fd_pr__cap_mim_m3_1 l=4.85 w=4.85
X57 a_3699_2732# a_3651_3132# VSS SUB sky130_fd_pr__nfet_01v8 ad=0.8904 pd=4.42 as=0.8904 ps=4.42 w=1.68 l=0.15
X58 c1_3694_7100# a_2762_3364# sky130_fd_pr__cap_mim_m3_1 l=4.85 w=4.85
X59 c1_2500_5906# a_2762_3364# sky130_fd_pr__cap_mim_m3_1 l=4.85 w=4.85
.ends
