* NGSPICE file created from tt_if.ext - technology: sky130A

* Black-box entry subcircuit for sky130_fd_sc_hd__tapvpwrvgnd_1 abstract view
.subckt sky130_fd_sc_hd__tapvpwrvgnd_1 VGND VPWR
.ends

* Black-box entry subcircuit for sky130_fd_sc_hd__decap_3 abstract view
.subckt sky130_fd_sc_hd__decap_3 VGND VNB VPB VPWR
.ends

* Black-box entry subcircuit for sky130_fd_sc_hd__decap_4 abstract view
.subckt sky130_fd_sc_hd__decap_4 VGND VNB VPB VPWR
.ends

* Black-box entry subcircuit for sky130_fd_sc_hd__conb_1 abstract view
.subckt sky130_fd_sc_hd__conb_1 VGND VNB VPB VPWR HI LO
.ends

* Black-box entry subcircuit for sky130_fd_sc_hd__fill_1 abstract view
.subckt sky130_fd_sc_hd__fill_1 VGND VNB VPB VPWR
.ends

* Black-box entry subcircuit for sky130_fd_sc_hd__decap_8 abstract view
.subckt sky130_fd_sc_hd__decap_8 VGND VNB VPB VPWR
.ends

* Black-box entry subcircuit for sky130_fd_sc_hd__clkbuf_16 abstract view
.subckt sky130_fd_sc_hd__clkbuf_16 A VGND VNB VPB VPWR X
.ends

* Black-box entry subcircuit for sky130_fd_sc_hd__xnor2_1 abstract view
.subckt sky130_fd_sc_hd__xnor2_1 A B VGND VNB VPB VPWR Y
.ends

* Black-box entry subcircuit for sky130_ef_sc_hd__decap_12 abstract view
.subckt sky130_ef_sc_hd__decap_12 VPWR VGND VPB VNB
.ends

* Black-box entry subcircuit for sky130_fd_sc_hd__nand2_1 abstract view
.subckt sky130_fd_sc_hd__nand2_1 A B VGND VNB VPB VPWR Y
.ends

* Black-box entry subcircuit for sky130_fd_sc_hd__decap_6 abstract view
.subckt sky130_fd_sc_hd__decap_6 VGND VNB VPB VPWR
.ends

* Black-box entry subcircuit for sky130_fd_sc_hd__clkbuf_1 abstract view
.subckt sky130_fd_sc_hd__clkbuf_1 A VGND VNB VPB VPWR X
.ends

* Black-box entry subcircuit for sky130_fd_sc_hd__dlymetal6s2s_1 abstract view
.subckt sky130_fd_sc_hd__dlymetal6s2s_1 A VGND VNB VPB VPWR X
.ends

* Black-box entry subcircuit for sky130_fd_sc_hd__dlygate4sd3_1 abstract view
.subckt sky130_fd_sc_hd__dlygate4sd3_1 A VGND VNB VPB VPWR X
.ends

* Black-box entry subcircuit for sky130_fd_sc_hd__dfrtp_1 abstract view
.subckt sky130_fd_sc_hd__dfrtp_1 CLK D RESET_B VGND VNB VPB VPWR Q
.ends

* Black-box entry subcircuit for sky130_fd_sc_hd__and2_1 abstract view
.subckt sky130_fd_sc_hd__and2_1 A B VGND VNB VPB VPWR X
.ends

* Black-box entry subcircuit for sky130_fd_sc_hd__fill_2 abstract view
.subckt sky130_fd_sc_hd__fill_2 VGND VNB VPB VPWR
.ends

* Black-box entry subcircuit for sky130_fd_sc_hd__or2_1 abstract view
.subckt sky130_fd_sc_hd__or2_1 A B VGND VNB VPB VPWR X
.ends

* Black-box entry subcircuit for sky130_fd_sc_hd__xor2_1 abstract view
.subckt sky130_fd_sc_hd__xor2_1 A B VGND VNB VPB VPWR X
.ends

* Black-box entry subcircuit for sky130_fd_sc_hd__and2b_1 abstract view
.subckt sky130_fd_sc_hd__and2b_1 A_N B VGND VNB VPB VPWR X
.ends

* Black-box entry subcircuit for sky130_fd_sc_hd__a31o_1 abstract view
.subckt sky130_fd_sc_hd__a31o_1 A1 A2 A3 B1 VGND VNB VPB VPWR X
.ends

* Black-box entry subcircuit for sky130_fd_sc_hd__and4_1 abstract view
.subckt sky130_fd_sc_hd__and4_1 A B C D VGND VNB VPB VPWR X
.ends

* Black-box entry subcircuit for sky130_fd_sc_hd__buf_2 abstract view
.subckt sky130_fd_sc_hd__buf_2 A VGND VNB VPB VPWR X
.ends

.subckt tt_if VDD VSS i_clk i_ena i_rst_n ui_in[0] ui_in[1] ui_in[2] ui_in[3] ui_in[4]
+ ui_in[5] ui_in[6] ui_in[7] uio_in[0] uio_in[1] uio_in[2] uio_in[3] uio_in[4] uio_in[5]
+ uio_in[6] uio_in[7] uio_oe[0] uio_oe[1] uio_oe[2] uio_oe[3] uio_oe[4] uio_oe[5]
+ uio_oe[6] uio_oe[7] uio_out[0] uio_out[1] uio_out[2] uio_out[3] uio_out[4] uio_out[5]
+ uio_out[6] uio_out[7] uo_out[0] uo_out[1] uo_out[2] uo_out[3] uo_out[4] uo_out[5]
+ uo_out[6] uo_out[7]
XTAP_TAPCELL_ROW_8_22 VSS VDD sky130_fd_sc_hd__tapvpwrvgnd_1
XPHY_EDGE_ROW_4_Left_13 VSS VSS VDD VDD sky130_fd_sc_hd__decap_3
XFILLER_0_24 VSS VSS VDD VDD sky130_fd_sc_hd__decap_4
Xtt_if_9 VSS VSS VDD VDD tt_if_9/HI uio_oe[2] sky130_fd_sc_hd__conb_1
Xtt_if_24 VSS VSS VDD VDD tt_if_24/HI uo_out[5] sky130_fd_sc_hd__conb_1
Xtt_if_13 VSS VSS VDD VDD tt_if_13/HI uio_oe[6] sky130_fd_sc_hd__conb_1
XFILLER_3_35 VSS VSS VDD VDD sky130_fd_sc_hd__fill_1
Xtt_if_25 VSS VSS VDD VDD tt_if_25/HI uo_out[6] sky130_fd_sc_hd__conb_1
Xtt_if_14 VSS VSS VDD VDD tt_if_14/HI uio_oe[7] sky130_fd_sc_hd__conb_1
XPHY_EDGE_ROW_6_Right_6 VSS VSS VDD VDD sky130_fd_sc_hd__decap_3
XFILLER_3_3 VSS VSS VDD VDD sky130_fd_sc_hd__decap_8
Xtt_if_26 VSS VSS VDD VDD tt_if_26/HI uo_out[7] sky130_fd_sc_hd__conb_1
Xtt_if_15 VSS VSS VDD VDD tt_if_15/HI uio_out[0] sky130_fd_sc_hd__conb_1
XPHY_EDGE_ROW_8_Left_17 VSS VSS VDD VDD sky130_fd_sc_hd__decap_3
XFILLER_0_49 VSS VSS VDD VDD sky130_fd_sc_hd__decap_3
Xtt_if_16 VSS VSS VDD VDD tt_if_16/HI uio_out[1] sky130_fd_sc_hd__conb_1
Xtt_if_17 VSS VSS VDD VDD tt_if_17/HI uio_out[2] sky130_fd_sc_hd__conb_1
XFILLER_6_27 VSS VSS VDD VDD sky130_fd_sc_hd__fill_1
Xclkbuf_0_i_clk i_clk VSS VSS VDD VDD clknet_0_i_clk sky130_fd_sc_hd__clkbuf_16
Xtt_if_18 VSS VSS VDD VDD tt_if_18/HI uio_out[3] sky130_fd_sc_hd__conb_1
Xtt_if_19 VSS VSS VDD VDD tt_if_19/HI uio_out[4] sky130_fd_sc_hd__conb_1
X_09_ net4 _04_ VSS VSS VDD VDD _00_ sky130_fd_sc_hd__xnor2_1
XTAP_TAPCELL_ROW_2_19 VSS VDD sky130_fd_sc_hd__tapvpwrvgnd_1
XPHY_EDGE_ROW_1_Right_1 VSS VSS VDD VDD sky130_fd_sc_hd__decap_3
XFILLER_6_29 VSS VSS VDD VDD sky130_fd_sc_hd__fill_1
XFILLER_3_19 VDD VSS VDD VSS sky130_ef_sc_hd__decap_12
X_08_ net3 net1 VSS VSS VDD VDD _04_ sky130_fd_sc_hd__nand2_1
XPHY_EDGE_ROW_3_Left_12 VSS VSS VDD VDD sky130_fd_sc_hd__decap_3
XFILLER_1_6 VSS VSS VDD VDD sky130_fd_sc_hd__decap_8
XFILLER_1_42 VSS VSS VDD VDD sky130_fd_sc_hd__decap_6
XPHY_EDGE_ROW_5_Right_5 VSS VSS VDD VDD sky130_fd_sc_hd__decap_3
XTAP_TAPCELL_ROW_6_21 VSS VDD sky130_fd_sc_hd__tapvpwrvgnd_1
XPHY_EDGE_ROW_0_Left_9 VSS VSS VDD VDD sky130_fd_sc_hd__decap_3
XPHY_EDGE_ROW_7_Left_16 VSS VSS VDD VDD sky130_fd_sc_hd__decap_3
XFILLER_7_22 VSS VSS VDD VDD sky130_fd_sc_hd__decap_4
Xinput1 net29 VSS VSS VDD VDD net1 sky130_fd_sc_hd__clkbuf_1
XFILLER_7_12 VSS VSS VDD VDD sky130_fd_sc_hd__decap_4
XFILLER_4_24 VSS VSS VDD VDD sky130_fd_sc_hd__decap_4
Xinput2 net27 VSS VSS VDD VDD net2 sky130_fd_sc_hd__dlymetal6s2s_1
XFILLER_1_48 VSS VSS VDD VDD sky130_fd_sc_hd__fill_1
XPHY_EDGE_ROW_0_Right_0 VSS VSS VDD VDD sky130_fd_sc_hd__decap_3
XFILLER_6_3 VSS VSS VDD VDD sky130_fd_sc_hd__decap_8
XPHY_EDGE_ROW_2_Left_11 VSS VSS VDD VDD sky130_fd_sc_hd__decap_3
XFILLER_7_16 VSS VSS VDD VDD sky130_fd_sc_hd__fill_1
XTAP_TAPCELL_ROW_0_18 VSS VDD sky130_fd_sc_hd__tapvpwrvgnd_1
XPHY_EDGE_ROW_4_Right_4 VSS VSS VDD VDD sky130_fd_sc_hd__decap_3
XFILLER_8_9 VSS VSS VDD VDD sky130_fd_sc_hd__fill_1
XPHY_EDGE_ROW_6_Left_15 VSS VSS VDD VDD sky130_fd_sc_hd__decap_3
XTAP_TAPCELL_ROW_4_20 VSS VDD sky130_fd_sc_hd__tapvpwrvgnd_1
Xhold1 i_rst_n VSS VSS VDD VDD net27 sky130_fd_sc_hd__dlygate4sd3_1
XPHY_EDGE_ROW_8_Right_8 VSS VSS VDD VDD sky130_fd_sc_hd__decap_3
XFILLER_4_6 VSS VSS VDD VDD sky130_fd_sc_hd__decap_4
Xhold2 net2 VSS VSS VDD VDD net28 sky130_fd_sc_hd__dlygate4sd3_1
XFILLER_8_20 VSS VSS VDD VDD sky130_fd_sc_hd__decap_4
X_19_ clknet_1_1__leaf_i_clk _03_ net28 VSS VSS VDD VDD net3 sky130_fd_sc_hd__dfrtp_1
Xhold3 i_ena VSS VSS VDD VDD net29 sky130_fd_sc_hd__dlygate4sd3_1
Xclkbuf_1_1__f_i_clk clknet_0_i_clk VSS VSS VDD VDD clknet_1_1__leaf_i_clk sky130_fd_sc_hd__clkbuf_16
Xhold4 _00_ VSS VSS VDD VDD net30 sky130_fd_sc_hd__dlygate4sd3_1
X_18_ clknet_1_0__leaf_i_clk _02_ net28 VSS VSS VDD VDD net6 sky130_fd_sc_hd__dfrtp_1
XPHY_EDGE_ROW_1_Left_10 VSS VSS VDD VDD sky130_fd_sc_hd__decap_3
XFILLER_2_6 VDD VSS VDD VSS sky130_ef_sc_hd__decap_12
X_17_ clknet_1_0__leaf_i_clk _01_ net28 VSS VSS VDD VDD net5 sky130_fd_sc_hd__dfrtp_1
Xhold5 net6 VSS VSS VDD VDD net31 sky130_fd_sc_hd__dlygate4sd3_1
XFILLER_2_25 VSS VSS VDD VDD sky130_fd_sc_hd__decap_3
X_16_ clknet_1_1__leaf_i_clk net30 net28 VSS VSS VDD VDD net4 sky130_fd_sc_hd__dfrtp_1
XFILLER_8_13 VSS VSS VDD VDD sky130_fd_sc_hd__decap_4
XPHY_EDGE_ROW_3_Right_3 VSS VSS VDD VDD sky130_fd_sc_hd__decap_3
XFILLER_5_14 VSS VSS VDD VDD sky130_fd_sc_hd__decap_3
X_15_ _04_ _07_ VSS VSS VDD VDD _03_ sky130_fd_sc_hd__and2_1
XFILLER_5_37 VSS VSS VDD VDD sky130_fd_sc_hd__fill_2
X_14_ net3 net1 VSS VSS VDD VDD _07_ sky130_fd_sc_hd__or2_1
XPHY_EDGE_ROW_5_Left_14 VSS VSS VDD VDD sky130_fd_sc_hd__decap_3
X_13_ net31 _05_ VSS VSS VDD VDD _02_ sky130_fd_sc_hd__xor2_1
XPHY_EDGE_ROW_7_Right_7 VSS VSS VDD VDD sky130_fd_sc_hd__decap_3
X_12_ _05_ _06_ VSS VSS VDD VDD _01_ sky130_fd_sc_hd__and2b_1
XFILLER_6_50 VSS VSS VDD VDD sky130_fd_sc_hd__fill_2
X_11_ net3 net4 net1 net5 VSS VSS VDD VDD _06_ sky130_fd_sc_hd__a31o_1
X_10_ net3 net4 net5 net1 VSS VSS VDD VDD _05_ sky130_fd_sc_hd__and4_1
Xtt_if_20 VSS VSS VDD VDD tt_if_20/HI uio_out[5] sky130_fd_sc_hd__conb_1
Xoutput3 net3 VSS VSS VDD VDD uo_out[0] sky130_fd_sc_hd__buf_2
XFILLER_3_31 VSS VSS VDD VDD sky130_fd_sc_hd__decap_4
Xtt_if_21 VSS VSS VDD VDD tt_if_21/HI uio_out[6] sky130_fd_sc_hd__conb_1
Xtt_if_10 VSS VSS VDD VDD tt_if_10/HI uio_oe[3] sky130_fd_sc_hd__conb_1
Xoutput4 net4 VSS VSS VDD VDD uo_out[1] sky130_fd_sc_hd__buf_2
Xclkbuf_1_0__f_i_clk clknet_0_i_clk VSS VSS VDD VDD clknet_1_0__leaf_i_clk sky130_fd_sc_hd__clkbuf_16
Xtt_if_7 VSS VSS VDD VDD tt_if_7/HI uio_oe[0] sky130_fd_sc_hd__conb_1
XPHY_EDGE_ROW_2_Right_2 VSS VSS VDD VDD sky130_fd_sc_hd__decap_3
Xtt_if_22 VSS VSS VDD VDD tt_if_22/HI uio_out[7] sky130_fd_sc_hd__conb_1
Xtt_if_11 VSS VSS VDD VDD tt_if_11/HI uio_oe[4] sky130_fd_sc_hd__conb_1
Xoutput5 net5 VSS VSS VDD VDD uo_out[2] sky130_fd_sc_hd__buf_2
XFILLER_3_11 VSS VSS VDD VDD sky130_fd_sc_hd__fill_2
XFILLER_0_12 VDD VSS VDD VSS sky130_ef_sc_hd__decap_12
Xtt_if_8 VSS VSS VDD VDD tt_if_8/HI uio_oe[1] sky130_fd_sc_hd__conb_1
Xtt_if_23 VSS VSS VDD VDD tt_if_23/HI uo_out[4] sky130_fd_sc_hd__conb_1
Xtt_if_12 VSS VSS VDD VDD tt_if_12/HI uio_oe[5] sky130_fd_sc_hd__conb_1
Xoutput6 net6 VSS VSS VDD VDD uo_out[3] sky130_fd_sc_hd__buf_2
XFILLER_6_11 VSS VSS VDD VDD sky130_fd_sc_hd__fill_1
.ends
