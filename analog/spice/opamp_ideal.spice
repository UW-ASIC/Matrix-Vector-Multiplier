.subckt opamp_ideal vip vim vout vdd vss ibias

* Ideal OpAmp Model (Single-Ended Output)
* High Gain VCVS + Input Impedance + Output Impedance
* Output swings relative to mid-rail (vdd+vss)/2

* Input Impedance
R_in_diff vip vim 100Meg

* Output Stage
* Internal VCVS drives 'v_int'
* Gain 1000 (60dB), clamped to rails.
* Offset added to center output at common mode.

B_gain v_int 0 V = 'Min(Max( (v(vip)-v(vim)) * 1000 + (v(vdd)+v(vss))/2 , v(vss)+0.01 ), v(vdd)-0.01 )'

* Output Impedance
R_out v_int vout 50

* Dummy bias pin load
R_bias ibias 0 10k

.ends
