.subckt DAC B0 B0_bar B1 B2 B3 B1_bar B2_bar B3_bar B4 B4_bar B5 B6 B7 B5_bar B6_bar B7_bar I_out_p v_in I_out_n I_main

* Ideal R2R DAC Model (Behavioral)
* Pins matched to StaticTest generation order:
* [Digital (16)] [Output] [Vin] [OutN] [Bias]
*
* v_in replaces vdd (1.8V usually)

* I_out_p = (I_main / 256) * (B0*1 + B1*2 + ... + B7*128)
* Assuming digital inputs are normalized to 1.8V

B_ideals 0 I_out_p I = (10u / 256) * (
+ (v(B0)/1.8) * 1 +
+ (v(B1)/1.8) * 2 +
+ (v(B2)/1.8) * 4 +
+ (v(B3)/1.8) * 8 +
+ (v(B4)/1.8) * 16 +
+ (v(B5)/1.8) * 32 +
+ (v(B6)/1.8) * 64 +
+ (v(B7)/1.8) * 128
+ )

* Dummy connections. I_main driven by 10u current source -> R=1k -> 10mV
R_dummy_n I_out_n 0 1k
R_dummy_vin v_in 0 1G
R_dummy_imain I_main 0 1k
R_dummy_b0_bar B0_bar 0 1G
R_dummy_b1_bar B1_bar 0 1G
R_dummy_b2_bar B2_bar 0 1G
R_dummy_b3_bar B3_bar 0 1G
R_dummy_b4_bar B4_bar 0 1G
R_dummy_b5_bar B5_bar 0 1G
R_dummy_b6_bar B6_bar 0 1G
R_dummy_b7_bar B7_bar 0 1G

.ends
