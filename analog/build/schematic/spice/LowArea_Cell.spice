** sch_path: /home/omare/Documents/UWASIC/Matrix-Vector-Analog/analog/library/CurrentMultiplier/LowArea_Cell.sch
**.subckt LowArea_Cell Iin Iout
*.ipin Iin
*.opin Iout
XM1 Iout Iin VSS GND sky130_fd_pr__nfet_01v8_lvt L=0.15 W=1 nf=1 ad='int((nf+1)/2) * W/nf * 0.29' as='int((nf+2)/2) * W/nf * 0.29'
+ pd='2*int((nf+1)/2) * (W/nf + 0.29)' ps='2*int((nf+2)/2) * (W/nf + 0.29)' nrd='0.29 / W' nrs='0.29 / W'
+ sa=0 sb=0 sd=0 mult=1 m=1
XR1 GND Iin GND sky130_fd_pr__res_high_po_5p73 L=11 mult=1 m=1
**.ends
.GLOBAL GND
.GLOBAL VSS
.end
