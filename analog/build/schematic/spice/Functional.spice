** sch_path: /home/omare/Documents/UWASIC/Matrix-Vector-Analog/analog/library/CurrentMultiplier/testbenches/Functional.sch
**.subckt Functional
x1 net3 net2 net1 CurrentMultiplier_LowArea
I1 VDD net2 2.5u
I2 VDD net1 1.5u
Vmeas net3 GND 0V
V1 VDD GND 1.8V
V2 VSS GND -1.8V
**** begin user architecture code

.control
save all
op
print i(Vmeas)
print v(net1) v(net2) v(net3)
* Measure resistance indirectly: R = V/I
print v(x.x1.x1.iin) v(x.x1.x1.gnd)
print i(v.x1.x1.xr1)
* Or try different syntax for subcircuit resistor
print @x.x1.x1.xr1.xsky130_fd_pr__res_high_po_5p73[resistance]
* Transistor parameters from LowArea_Cell
print @m.x1.x1.xm1.msky130_fd_pr__nfet_01v8_lvt[gm]
print @m.x1.x1.xm1.msky130_fd_pr__nfet_01v8_lvt[vth]
print @m.x1.x1.xm1.msky130_fd_pr__nfet_01v8_lvt[vdsat]
print @m.x1.x1.xm1.msky130_fd_pr__nfet_01v8_lvt[id]
* Calculate Ix and Iy
print (2.5e-6+1.5e-6)/2
print (2.5e-6-1.5e-6)/2
.endc

.param mc_mm_switch=0
.param mc_pr_switch=0
.include /home/omare/.volare/sky130A/libs.tech/ngspice/corners/tt.spice
.include /home/omare/.volare/sky130A/libs.tech/ngspice/r+c/res_typical__cap_typical.spice
.include /home/omare/.volare/sky130A/libs.tech/ngspice/r+c/res_typical__cap_typical__lin.spice
.include /home/omare/.volare/sky130A/libs.tech/ngspice/corners/tt/specialized_cells.spice

**** end user architecture code
**.ends

* expanding   symbol:  CurrentMultiplier/CurrentMultiplier_LowArea.sym # of pins=3
** sym_path: /home/omare/Documents/UWASIC/Matrix-Vector-Analog/analog/library/CurrentMultiplier/CurrentMultiplier_LowArea.sym
** sch_path: /home/omare/Documents/UWASIC/Matrix-Vector-Analog/analog/library/CurrentMultiplier/CurrentMultiplier_LowArea.sch
.subckt CurrentMultiplier_LowArea Iout I1 I2
*.opin Iout
*.ipin I1
*.ipin I2
x1 I1 Io1 LowArea_Cell
x2 net1 Io1 LowArea_Cell
x3 I2 Iout LowArea_Cell
x4 net2 Iout LowArea_Cell
XM1 Io1 Io1 VDD VDD sky130_fd_pr__pfet_01v8 L=0.15 W=1 nf=1 ad='int((nf+1)/2) * W/nf * 0.29' as='int((nf+2)/2) * W/nf * 0.29'
+ pd='2*int((nf+1)/2) * (W/nf + 0.29)' ps='2*int((nf+2)/2) * (W/nf + 0.29)' nrd='0.29 / W' nrs='0.29 / W'
+ sa=0 sb=0 sd=0 mult=1 m=1
XM2 Iout Io1 VDD VDD sky130_fd_pr__pfet_01v8 L=0.15 W=1 nf=1 ad='int((nf+1)/2) * W/nf * 0.29' as='int((nf+2)/2) * W/nf * 0.29'
+ pd='2*int((nf+1)/2) * (W/nf + 0.29)' ps='2*int((nf+2)/2) * (W/nf + 0.29)' nrd='0.29 / W' nrs='0.29 / W'
+ sa=0 sb=0 sd=0 mult=1 m=1
XM3 net1 I1 GND GND sky130_fd_pr__nfet_01v8 L=0.15 W=1 nf=1 ad='int((nf+1)/2) * W/nf * 0.29' as='int((nf+2)/2) * W/nf * 0.29'
+ pd='2*int((nf+1)/2) * (W/nf + 0.29)' ps='2*int((nf+2)/2) * (W/nf + 0.29)' nrd='0.29 / W' nrs='0.29 / W'
+ sa=0 sb=0 sd=0 mult=1 m=1
XM4 I1 I1 GND GND sky130_fd_pr__nfet_01v8 L=0.15 W=1 nf=1 ad='int((nf+1)/2) * W/nf * 0.29' as='int((nf+2)/2) * W/nf * 0.29'
+ pd='2*int((nf+1)/2) * (W/nf + 0.29)' ps='2*int((nf+2)/2) * (W/nf + 0.29)' nrd='0.29 / W' nrs='0.29 / W'
+ sa=0 sb=0 sd=0 mult=1 m=1
XM5 net2 I2 GND GND sky130_fd_pr__nfet_01v8 L=0.15 W=1 nf=1 ad='int((nf+1)/2) * W/nf * 0.29' as='int((nf+2)/2) * W/nf * 0.29'
+ pd='2*int((nf+1)/2) * (W/nf + 0.29)' ps='2*int((nf+2)/2) * (W/nf + 0.29)' nrd='0.29 / W' nrs='0.29 / W'
+ sa=0 sb=0 sd=0 mult=1 m=1
XM6 I2 I2 GND GND sky130_fd_pr__nfet_01v8 L=0.15 W=1 nf=1 ad='int((nf+1)/2) * W/nf * 0.29' as='int((nf+2)/2) * W/nf * 0.29'
+ pd='2*int((nf+1)/2) * (W/nf + 0.29)' ps='2*int((nf+2)/2) * (W/nf + 0.29)' nrd='0.29 / W' nrs='0.29 / W'
+ sa=0 sb=0 sd=0 mult=1 m=1
.ends

* expanding   symbol:  CurrentMultiplier/LowArea_Cell.sym # of pins=2
** sym_path: /home/omare/Documents/UWASIC/Matrix-Vector-Analog/analog/library/CurrentMultiplier/LowArea_Cell.sym
** sch_path: /home/omare/Documents/UWASIC/Matrix-Vector-Analog/analog/library/CurrentMultiplier/LowArea_Cell.sch
.subckt LowArea_Cell Iout Iin
*.ipin Iin
*.opin Iout
XM1 Iout Iin VSS GND sky130_fd_pr__nfet_01v8_lvt L=0.15 W=1 nf=1 ad='int((nf+1)/2) * W/nf * 0.29' as='int((nf+2)/2) * W/nf * 0.29'
+ pd='2*int((nf+1)/2) * (W/nf + 0.29)' ps='2*int((nf+2)/2) * (W/nf + 0.29)' nrd='0.29 / W' nrs='0.29 / W'
+ sa=0 sb=0 sd=0 mult=1 m=1
XR1 GND Iin GND sky130_fd_pr__res_high_po_5p73 L=11 mult=1 m=1
.ends

.GLOBAL VDD
.GLOBAL VSS
.GLOBAL GND
.end
