** sch_path: /home/david/Documents/Matrix-Vector-Multiplier/analog/schematics/testbenches/seg_dac_tb.sch
**.subckt seg_dac_tb
x1 V_in I_main I_out_n I_out_p T1 T3 T4 B3 T2 T0 B4 T5 B2 B0 T6 B1 T1_n T0_n B2_n T5_n T4_n T3_n B1_n B4_n T2_n B3_n T6_n B0_n
+ segmented_dac
V4 B0 GND PULSE(0 1.8 0 100p 100p 15.15n 30.3n)
V5 B1 GND PULSE(0 1.8 0 100p 100p 30.3n 60.6n)
V6 B2 GND PULSE(0 1.8 0 100p 100p 60.6n 121.2n)
V7 B3 GND PULSE(0 1.8 0 100p 100p 121.2n 242.4n)
V8 B4 GND PULSE(0 1.8 0 100p 100p 242.4n 484.8n)
V9 T0 GND PULSE(0 1.8 0 100p 100p 484.8n 7756.8n)
V10 T1 GND PULSE(0 1.8 0 100p 100p 969.6n 7756.8n)
V11 T2 GND PULSE(0 1.8 0 100p 100p 1454.4n 7756.8n)
V17 T3 GND PULSE(0 1.8 0 100p 100p 1939.2n 7756.8n)
V18 T4 GND PULSE(0 1.8 0 100p 100p 2424n 7756.8n)
V19 T5 GND PULSE(0 1.8 0 100p 100p 2908.8n 7756.8n)
V20 T6 GND PULSE(0 1.8 0 100p 100p 3393.6n 7756.8n)
V12 B0_n GND PULSE(1.8 0 0 100p 100p 15.15n 30.3n)
V13 B1_n GND PULSE(1.8 0 0 100p 100p 30.3n 60.6n)
V14 B2_n GND PULSE(1.8 0 0 100p 100p 60.6n 121.2n)
V15 B3_n GND PULSE(1.8 0 0 100p 100p 121.2n 242.4n)
V16 B4_n GND PULSE(1.8 0 0 100p 100p 242.4n 484.8n)
V21 T0_n GND PULSE(1.8 0 0 100p 100p 484.8n 7756.8n)
V22 T1_n GND PULSE(1.8 0 0 100p 100p 969.6n 7756.8n)
V23 T2_n GND PULSE(1.8 0 0 100p 100p 1454.4n 7756.8n)
V24 T3_n GND PULSE(1.8 0 0 100p 100p 1939.2n 7756.8n)
V25 T4_n GND PULSE(1.8 0 0 100p 100p 2424n 7756.8n)
V26 T5_n GND PULSE(1.8 0 0 100p 100p 2908.8n 7756.8n)
V27 T6_n GND PULSE(1.8 0 0 100p 100p 3393.6n 7756.8n)
R5 net3 GND 1k m=1
x2 net1 v_dac_out_p I_out_p GND net4 GND OpAmp
V2 net4 GND 0.9
V3 net1 GND 1.8
R4 v_dac_out_p I_out_p 1k m=1
R1 GND v_dac_out_p 1k m=1
x3 net2 v_dac_out_n I_out_n GND net5 GND OpAmp
R6 v_dac_out_n I_out_n 1k m=1
R3 GND v_dac_out_n 1k m=1
V1 V_in GND 1.8
V28 I_main net3 0
V29 net5 GND 0.9
V30 net2 GND 1.8
**** begin user architecture code
.lib /home/david/.volare/sky130A/libs.tech/ngspice/sky130.lib.spice tt

.control
* Longer simulation with slower switching
tran 25p 3878.4n
* Plot differential output
let diff_out = v_dac_out_p - v_dac_out_n
plot diff_out

* Also plot individual outputs to see if one is noisier
plot v_dac_out_p v_dac_out_n

write seg_dac_tb.raw
.endc

.end

**** end user architecture code
**.ends

* expanding   symbol:  segmented_dac.sym # of pins=28
** sym_path: /home/david/Documents/Matrix-Vector-Multiplier/analog/schematics/segmented_dac.sym
** sch_path: /home/david/Documents/Matrix-Vector-Multiplier/analog/schematics/segmented_dac.sch
.subckt segmented_dac V_in I_main I_out_n I_out_p T1 T3 T4 B3 T2 T0 B4 T5 B2 B0 T6 B1 T1_n T0_n B2_n T5_n T4_n T3_n B1_n B4_n T2_n
+ B3_n T6_n B0_n
*.ipin B0
*.ipin B0_n
*.ipin B1
*.ipin B2
*.ipin B3
*.ipin B1_n
*.ipin B2_n
*.ipin B3_n
*.ipin B4
*.ipin B4_n
*.ipin T0
*.ipin T1
*.ipin T2
*.ipin T0_n
*.ipin T1_n
*.ipin T2_n
*.opin I_out_p
*.ipin V_in
*.opin I_out_n
*.opin I_main
*.ipin T3
*.ipin T4
*.ipin T5
*.ipin T3_n
*.ipin T4_n
*.ipin T5_n
*.ipin T6
*.ipin T6_n
XM1 net2 net1 V_in V_in sky130_fd_pr__pfet_01v8 L=length W=min_width nf=1 ad='int((nf+1)/2) * W/nf * 0.29' as='int((nf+2)/2) * W/nf * 0.29'
+ pd='2*int((nf+1)/2) * (W/nf + 0.29)' ps='2*int((nf+2)/2) * (W/nf + 0.29)' nrd='0.29 / W' nrs='0.29 / W' sa=0 sb=0 sd=0 mult=32 m=32
XM2 net6 I_main net2 net2 sky130_fd_pr__pfet_01v8 L=length W=min_width nf=1 ad='int((nf+1)/2) * W/nf * 0.29' as='int((nf+2)/2) * W/nf * 0.29'
+ pd='2*int((nf+1)/2) * (W/nf + 0.29)' ps='2*int((nf+2)/2) * (W/nf + 0.29)' nrd='0.29 / W' nrs='0.29 / W' sa=0 sb=0 sd=0 mult=32 m=32
XM3 net1 net1 V_in V_in sky130_fd_pr__pfet_01v8 L=length W=min_width nf=1 ad='int((nf+1)/2) * W/nf * 0.29' as='int((nf+2)/2) * W/nf * 0.29'
+ pd='2*int((nf+1)/2) * (W/nf + 0.29)' ps='2*int((nf+2)/2) * (W/nf + 0.29)' nrd='0.29 / W' nrs='0.29 / W' sa=0 sb=0 sd=0 mult=128 m=128
XM4 I_main I_main net1 net1 sky130_fd_pr__pfet_01v8 L=length W=min_width nf=1 ad='int((nf+1)/2) * W/nf * 0.29' as='int((nf+2)/2) * W/nf * 0.29'
+ pd='2*int((nf+1)/2) * (W/nf + 0.29)' ps='2*int((nf+2)/2) * (W/nf + 0.29)' nrd='0.29 / W' nrs='0.29 / W' sa=0 sb=0 sd=0 mult=128 m=128
XM5 net3 net1 V_in V_in sky130_fd_pr__pfet_01v8 L=length W=min_width nf=1 ad='int((nf+1)/2) * W/nf * 0.29' as='int((nf+2)/2) * W/nf * 0.29'
+ pd='2*int((nf+1)/2) * (W/nf + 0.29)' ps='2*int((nf+2)/2) * (W/nf + 0.29)' nrd='0.29 / W' nrs='0.29 / W' sa=0 sb=0 sd=0 mult=32 m=32
XM6 net7 I_main net3 net3 sky130_fd_pr__pfet_01v8 L=length W=min_width nf=1 ad='int((nf+1)/2) * W/nf * 0.29' as='int((nf+2)/2) * W/nf * 0.29'
+ pd='2*int((nf+1)/2) * (W/nf + 0.29)' ps='2*int((nf+2)/2) * (W/nf + 0.29)' nrd='0.29 / W' nrs='0.29 / W' sa=0 sb=0 sd=0 mult=32 m=32
XM7 net4 net1 V_in V_in sky130_fd_pr__pfet_01v8 L=length W=min_width nf=1 ad='int((nf+1)/2) * W/nf * 0.29' as='int((nf+2)/2) * W/nf * 0.29'
+ pd='2*int((nf+1)/2) * (W/nf + 0.29)' ps='2*int((nf+2)/2) * (W/nf + 0.29)' nrd='0.29 / W' nrs='0.29 / W' sa=0 sb=0 sd=0 mult=32 m=32
XM8 net8 I_main net4 net4 sky130_fd_pr__pfet_01v8 L=length W=min_width nf=1 ad='int((nf+1)/2) * W/nf * 0.29' as='int((nf+2)/2) * W/nf * 0.29'
+ pd='2*int((nf+1)/2) * (W/nf + 0.29)' ps='2*int((nf+2)/2) * (W/nf + 0.29)' nrd='0.29 / W' nrs='0.29 / W' sa=0 sb=0 sd=0 mult=32 m=32
XM9 net5 net1 V_in V_in sky130_fd_pr__pfet_01v8 L=length W=min_width nf=1 ad='int((nf+1)/2) * W/nf * 0.29' as='int((nf+2)/2) * W/nf * 0.29'
+ pd='2*int((nf+1)/2) * (W/nf + 0.29)' ps='2*int((nf+2)/2) * (W/nf + 0.29)' nrd='0.29 / W' nrs='0.29 / W' sa=0 sb=0 sd=0 mult=16 m=16
XM10 net9 I_main net5 net5 sky130_fd_pr__pfet_01v8 L=length W=min_width nf=1 ad='int((nf+1)/2) * W/nf * 0.29' as='int((nf+2)/2) * W/nf * 0.29'
+ pd='2*int((nf+1)/2) * (W/nf + 0.29)' ps='2*int((nf+2)/2) * (W/nf + 0.29)' nrd='0.29 / W' nrs='0.29 / W' sa=0 sb=0 sd=0 mult=16 m=16
XM12 I_out_p T2 net6 net6 sky130_fd_pr__pfet_01v8 L=length W=min_width*switch_multiplier nf=1 ad='int((nf+1)/2) * W/nf * 0.29' as='int((nf+2)/2) * W/nf * 0.29'
+ pd='2*int((nf+1)/2) * (W/nf + 0.29)' ps='2*int((nf+2)/2) * (W/nf + 0.29)' nrd='0.29 / W' nrs='0.29 / W' sa=0 sb=0 sd=0 mult=32 m=32
XM13 I_out_n T2_n net6 net6 sky130_fd_pr__pfet_01v8 L=length W=min_width*switch_multiplier nf=1 ad='int((nf+1)/2) * W/nf * 0.29' as='int((nf+2)/2) * W/nf * 0.29'
+ pd='2*int((nf+1)/2) * (W/nf + 0.29)' ps='2*int((nf+2)/2) * (W/nf + 0.29)' nrd='0.29 / W' nrs='0.29 / W' sa=0 sb=0 sd=0 mult=32 m=32
XM14 I_out_p T1 net7 net7 sky130_fd_pr__pfet_01v8 L=length W=min_width*switch_multiplier nf=1 ad='int((nf+1)/2) * W/nf * 0.29' as='int((nf+2)/2) * W/nf * 0.29'
+ pd='2*int((nf+1)/2) * (W/nf + 0.29)' ps='2*int((nf+2)/2) * (W/nf + 0.29)' nrd='0.29 / W' nrs='0.29 / W' sa=0 sb=0 sd=0 mult=32 m=32
XM15 I_out_n T1_n net7 net7 sky130_fd_pr__pfet_01v8 L=length W=min_width*switch_multiplier nf=1 ad='int((nf+1)/2) * W/nf * 0.29' as='int((nf+2)/2) * W/nf * 0.29'
+ pd='2*int((nf+1)/2) * (W/nf + 0.29)' ps='2*int((nf+2)/2) * (W/nf + 0.29)' nrd='0.29 / W' nrs='0.29 / W' sa=0 sb=0 sd=0 mult=32 m=32
XM16 I_out_p T0 net8 net8 sky130_fd_pr__pfet_01v8 L=length W=min_width*switch_multiplier nf=1 ad='int((nf+1)/2) * W/nf * 0.29' as='int((nf+2)/2) * W/nf * 0.29'
+ pd='2*int((nf+1)/2) * (W/nf + 0.29)' ps='2*int((nf+2)/2) * (W/nf + 0.29)' nrd='0.29 / W' nrs='0.29 / W' sa=0 sb=0 sd=0 mult=32 m=32
XM17 I_out_n T0_n net8 net8 sky130_fd_pr__pfet_01v8 L=length W=min_width*switch_multiplier nf=1 ad='int((nf+1)/2) * W/nf * 0.29' as='int((nf+2)/2) * W/nf * 0.29'
+ pd='2*int((nf+1)/2) * (W/nf + 0.29)' ps='2*int((nf+2)/2) * (W/nf + 0.29)' nrd='0.29 / W' nrs='0.29 / W' sa=0 sb=0 sd=0 mult=32 m=32
XM18 I_out_p B4 net9 net9 sky130_fd_pr__pfet_01v8 L=length W=min_width*switch_multiplier nf=1 ad='int((nf+1)/2) * W/nf * 0.29' as='int((nf+2)/2) * W/nf * 0.29'
+ pd='2*int((nf+1)/2) * (W/nf + 0.29)' ps='2*int((nf+2)/2) * (W/nf + 0.29)' nrd='0.29 / W' nrs='0.29 / W' sa=0 sb=0 sd=0 mult=16 m=16
XM19 I_out_n B4_n net9 net9 sky130_fd_pr__pfet_01v8 L=length W=min_width*switch_multiplier nf=1 ad='int((nf+1)/2) * W/nf * 0.29' as='int((nf+2)/2) * W/nf * 0.29'
+ pd='2*int((nf+1)/2) * (W/nf + 0.29)' ps='2*int((nf+2)/2) * (W/nf + 0.29)' nrd='0.29 / W' nrs='0.29 / W' sa=0 sb=0 sd=0 mult=16 m=16
XM11 net10 net1 V_in V_in sky130_fd_pr__pfet_01v8 L=length W=min_width nf=1 ad='int((nf+1)/2) * W/nf * 0.29' as='int((nf+2)/2) * W/nf * 0.29'
+ pd='2*int((nf+1)/2) * (W/nf + 0.29)' ps='2*int((nf+2)/2) * (W/nf + 0.29)' nrd='0.29 / W' nrs='0.29 / W' sa=0 sb=0 sd=0 mult=8 m=8
XM20 net14 I_main net10 net10 sky130_fd_pr__pfet_01v8 L=length W=min_width nf=1 ad='int((nf+1)/2) * W/nf * 0.29' as='int((nf+2)/2) * W/nf * 0.29'
+ pd='2*int((nf+1)/2) * (W/nf + 0.29)' ps='2*int((nf+2)/2) * (W/nf + 0.29)' nrd='0.29 / W' nrs='0.29 / W' sa=0 sb=0 sd=0 mult=8 m=8
XM21 net11 net1 V_in V_in sky130_fd_pr__pfet_01v8 L=length W=min_width nf=1 ad='int((nf+1)/2) * W/nf * 0.29' as='int((nf+2)/2) * W/nf * 0.29'
+ pd='2*int((nf+1)/2) * (W/nf + 0.29)' ps='2*int((nf+2)/2) * (W/nf + 0.29)' nrd='0.29 / W' nrs='0.29 / W' sa=0 sb=0 sd=0 mult=4 m=4
XM22 net15 I_main net11 net11 sky130_fd_pr__pfet_01v8 L=length W=min_width nf=1 ad='int((nf+1)/2) * W/nf * 0.29' as='int((nf+2)/2) * W/nf * 0.29'
+ pd='2*int((nf+1)/2) * (W/nf + 0.29)' ps='2*int((nf+2)/2) * (W/nf + 0.29)' nrd='0.29 / W' nrs='0.29 / W' sa=0 sb=0 sd=0 mult=4 m=4
XM23 net12 net1 V_in V_in sky130_fd_pr__pfet_01v8 L=length W=min_width nf=1 ad='int((nf+1)/2) * W/nf * 0.29' as='int((nf+2)/2) * W/nf * 0.29'
+ pd='2*int((nf+1)/2) * (W/nf + 0.29)' ps='2*int((nf+2)/2) * (W/nf + 0.29)' nrd='0.29 / W' nrs='0.29 / W' sa=0 sb=0 sd=0 mult=2 m=2
XM24 net16 I_main net12 net12 sky130_fd_pr__pfet_01v8 L=length W=min_width nf=1 ad='int((nf+1)/2) * W/nf * 0.29' as='int((nf+2)/2) * W/nf * 0.29'
+ pd='2*int((nf+1)/2) * (W/nf + 0.29)' ps='2*int((nf+2)/2) * (W/nf + 0.29)' nrd='0.29 / W' nrs='0.29 / W' sa=0 sb=0 sd=0 mult=2 m=2
XM25 net13 net1 V_in V_in sky130_fd_pr__pfet_01v8 L=length W=min_width nf=1 ad='int((nf+1)/2) * W/nf * 0.29' as='int((nf+2)/2) * W/nf * 0.29'
+ pd='2*int((nf+1)/2) * (W/nf + 0.29)' ps='2*int((nf+2)/2) * (W/nf + 0.29)' nrd='0.29 / W' nrs='0.29 / W' sa=0 sb=0 sd=0 mult=1 m=1
XM26 net17 I_main net13 net13 sky130_fd_pr__pfet_01v8 L=length W=min_width nf=1 ad='int((nf+1)/2) * W/nf * 0.29' as='int((nf+2)/2) * W/nf * 0.29'
+ pd='2*int((nf+1)/2) * (W/nf + 0.29)' ps='2*int((nf+2)/2) * (W/nf + 0.29)' nrd='0.29 / W' nrs='0.29 / W' sa=0 sb=0 sd=0 mult=1 m=1
XM27 I_out_p B3 net14 net14 sky130_fd_pr__pfet_01v8 L=length W=min_width*switch_multiplier nf=1 ad='int((nf+1)/2) * W/nf * 0.29' as='int((nf+2)/2) * W/nf * 0.29'
+ pd='2*int((nf+1)/2) * (W/nf + 0.29)' ps='2*int((nf+2)/2) * (W/nf + 0.29)' nrd='0.29 / W' nrs='0.29 / W' sa=0 sb=0 sd=0 mult=8 m=8
XM28 I_out_n B3_n net14 net14 sky130_fd_pr__pfet_01v8 L=length W=min_width*switch_multiplier nf=1 ad='int((nf+1)/2) * W/nf * 0.29'
+ as='int((nf+2)/2) * W/nf * 0.29' pd='2*int((nf+1)/2) * (W/nf + 0.29)' ps='2*int((nf+2)/2) * (W/nf + 0.29)' nrd='0.29 / W' nrs='0.29 / W'
+ sa=0 sb=0 sd=0 mult=8 m=8
XM29 I_out_p B2 net15 net15 sky130_fd_pr__pfet_01v8 L=length W=min_width*switch_multiplier nf=1 ad='int((nf+1)/2) * W/nf * 0.29' as='int((nf+2)/2) * W/nf * 0.29'
+ pd='2*int((nf+1)/2) * (W/nf + 0.29)' ps='2*int((nf+2)/2) * (W/nf + 0.29)' nrd='0.29 / W' nrs='0.29 / W' sa=0 sb=0 sd=0 mult=4 m=4
XM30 I_out_n B2_n net15 net15 sky130_fd_pr__pfet_01v8 L=length W=min_width*switch_multiplier nf=1 ad='int((nf+1)/2) * W/nf * 0.29'
+ as='int((nf+2)/2) * W/nf * 0.29' pd='2*int((nf+1)/2) * (W/nf + 0.29)' ps='2*int((nf+2)/2) * (W/nf + 0.29)' nrd='0.29 / W' nrs='0.29 / W'
+ sa=0 sb=0 sd=0 mult=4 m=4
XM31 I_out_p B1 net16 net16 sky130_fd_pr__pfet_01v8 L=length W=min_width*switch_multiplier nf=1 ad='int((nf+1)/2) * W/nf * 0.29' as='int((nf+2)/2) * W/nf * 0.29'
+ pd='2*int((nf+1)/2) * (W/nf + 0.29)' ps='2*int((nf+2)/2) * (W/nf + 0.29)' nrd='0.29 / W' nrs='0.29 / W' sa=0 sb=0 sd=0 mult=2 m=2
XM32 I_out_n B1_n net16 net16 sky130_fd_pr__pfet_01v8 L=length W=min_width*switch_multiplier nf=1 ad='int((nf+1)/2) * W/nf * 0.29'
+ as='int((nf+2)/2) * W/nf * 0.29' pd='2*int((nf+1)/2) * (W/nf + 0.29)' ps='2*int((nf+2)/2) * (W/nf + 0.29)' nrd='0.29 / W' nrs='0.29 / W'
+ sa=0 sb=0 sd=0 mult=2 m=2
XM33 I_out_p B0 net17 net17 sky130_fd_pr__pfet_01v8 L=length W=min_width*switch_multiplier nf=1 ad='int((nf+1)/2) * W/nf * 0.29' as='int((nf+2)/2) * W/nf * 0.29'
+ pd='2*int((nf+1)/2) * (W/nf + 0.29)' ps='2*int((nf+2)/2) * (W/nf + 0.29)' nrd='0.29 / W' nrs='0.29 / W' sa=0 sb=0 sd=0 mult=1 m=1
XM34 I_out_n B0_n net17 net17 sky130_fd_pr__pfet_01v8 L=length W=min_width*switch_multiplier nf=1 ad='int((nf+1)/2) * W/nf * 0.29'
+ as='int((nf+2)/2) * W/nf * 0.29' pd='2*int((nf+1)/2) * (W/nf + 0.29)' ps='2*int((nf+2)/2) * (W/nf + 0.29)' nrd='0.29 / W' nrs='0.29 / W'
+ sa=0 sb=0 sd=0 mult=1 m=1
**** begin user architecture code

.param min_width=0.42
.param switch_multiplier=1
.param length=0.425

**** end user architecture code
XM35 net18 net1 V_in V_in sky130_fd_pr__pfet_01v8 L=length W=min_width nf=1 ad='int((nf+1)/2) * W/nf * 0.29' as='int((nf+2)/2) * W/nf * 0.29'
+ pd='2*int((nf+1)/2) * (W/nf + 0.29)' ps='2*int((nf+2)/2) * (W/nf + 0.29)' nrd='0.29 / W' nrs='0.29 / W' sa=0 sb=0 sd=0 mult=32 m=32
XM36 net21 I_main net18 net18 sky130_fd_pr__pfet_01v8 L=length W=min_width nf=1 ad='int((nf+1)/2) * W/nf * 0.29' as='int((nf+2)/2) * W/nf * 0.29'
+ pd='2*int((nf+1)/2) * (W/nf + 0.29)' ps='2*int((nf+2)/2) * (W/nf + 0.29)' nrd='0.29 / W' nrs='0.29 / W' sa=0 sb=0 sd=0 mult=32 m=32
XM37 net19 net1 V_in V_in sky130_fd_pr__pfet_01v8 L=length W=min_width nf=1 ad='int((nf+1)/2) * W/nf * 0.29' as='int((nf+2)/2) * W/nf * 0.29'
+ pd='2*int((nf+1)/2) * (W/nf + 0.29)' ps='2*int((nf+2)/2) * (W/nf + 0.29)' nrd='0.29 / W' nrs='0.29 / W' sa=0 sb=0 sd=0 mult=32 m=32
XM38 net22 I_main net19 net19 sky130_fd_pr__pfet_01v8 L=length W=min_width nf=1 ad='int((nf+1)/2) * W/nf * 0.29' as='int((nf+2)/2) * W/nf * 0.29'
+ pd='2*int((nf+1)/2) * (W/nf + 0.29)' ps='2*int((nf+2)/2) * (W/nf + 0.29)' nrd='0.29 / W' nrs='0.29 / W' sa=0 sb=0 sd=0 mult=32 m=32
XM39 net20 net1 V_in V_in sky130_fd_pr__pfet_01v8 L=length W=min_width nf=1 ad='int((nf+1)/2) * W/nf * 0.29' as='int((nf+2)/2) * W/nf * 0.29'
+ pd='2*int((nf+1)/2) * (W/nf + 0.29)' ps='2*int((nf+2)/2) * (W/nf + 0.29)' nrd='0.29 / W' nrs='0.29 / W' sa=0 sb=0 sd=0 mult=32 m=32
XM40 net23 I_main net20 net20 sky130_fd_pr__pfet_01v8 L=length W=min_width nf=1 ad='int((nf+1)/2) * W/nf * 0.29' as='int((nf+2)/2) * W/nf * 0.29'
+ pd='2*int((nf+1)/2) * (W/nf + 0.29)' ps='2*int((nf+2)/2) * (W/nf + 0.29)' nrd='0.29 / W' nrs='0.29 / W' sa=0 sb=0 sd=0 mult=32 m=32
XM41 I_out_p T5 net21 net21 sky130_fd_pr__pfet_01v8 L=length W=min_width*switch_multiplier nf=1 ad='int((nf+1)/2) * W/nf * 0.29' as='int((nf+2)/2) * W/nf * 0.29'
+ pd='2*int((nf+1)/2) * (W/nf + 0.29)' ps='2*int((nf+2)/2) * (W/nf + 0.29)' nrd='0.29 / W' nrs='0.29 / W' sa=0 sb=0 sd=0 mult=32 m=32
XM42 I_out_n T5_n net21 net21 sky130_fd_pr__pfet_01v8 L=length W=min_width*switch_multiplier nf=1 ad='int((nf+1)/2) * W/nf * 0.29'
+ as='int((nf+2)/2) * W/nf * 0.29' pd='2*int((nf+1)/2) * (W/nf + 0.29)' ps='2*int((nf+2)/2) * (W/nf + 0.29)' nrd='0.29 / W' nrs='0.29 / W'
+ sa=0 sb=0 sd=0 mult=32 m=32
XM43 I_out_p T4 net22 net22 sky130_fd_pr__pfet_01v8 L=length W=min_width*switch_multiplier nf=1 ad='int((nf+1)/2) * W/nf * 0.29' as='int((nf+2)/2) * W/nf * 0.29'
+ pd='2*int((nf+1)/2) * (W/nf + 0.29)' ps='2*int((nf+2)/2) * (W/nf + 0.29)' nrd='0.29 / W' nrs='0.29 / W' sa=0 sb=0 sd=0 mult=32 m=32
XM44 I_out_n T4_n net22 net22 sky130_fd_pr__pfet_01v8 L=length W=min_width*switch_multiplier nf=1 ad='int((nf+1)/2) * W/nf * 0.29'
+ as='int((nf+2)/2) * W/nf * 0.29' pd='2*int((nf+1)/2) * (W/nf + 0.29)' ps='2*int((nf+2)/2) * (W/nf + 0.29)' nrd='0.29 / W' nrs='0.29 / W'
+ sa=0 sb=0 sd=0 mult=32 m=32
XM45 I_out_p T3 net23 net23 sky130_fd_pr__pfet_01v8 L=length W=min_width*switch_multiplier nf=1 ad='int((nf+1)/2) * W/nf * 0.29' as='int((nf+2)/2) * W/nf * 0.29'
+ pd='2*int((nf+1)/2) * (W/nf + 0.29)' ps='2*int((nf+2)/2) * (W/nf + 0.29)' nrd='0.29 / W' nrs='0.29 / W' sa=0 sb=0 sd=0 mult=32 m=32
XM46 I_out_n T3_n net23 net23 sky130_fd_pr__pfet_01v8 L=length W=min_width*switch_multiplier nf=1 ad='int((nf+1)/2) * W/nf * 0.29'
+ as='int((nf+2)/2) * W/nf * 0.29' pd='2*int((nf+1)/2) * (W/nf + 0.29)' ps='2*int((nf+2)/2) * (W/nf + 0.29)' nrd='0.29 / W' nrs='0.29 / W'
+ sa=0 sb=0 sd=0 mult=32 m=32
XM47 net24 net1 V_in V_in sky130_fd_pr__pfet_01v8 L=length W=min_width nf=1 ad='int((nf+1)/2) * W/nf * 0.29' as='int((nf+2)/2) * W/nf * 0.29'
+ pd='2*int((nf+1)/2) * (W/nf + 0.29)' ps='2*int((nf+2)/2) * (W/nf + 0.29)' nrd='0.29 / W' nrs='0.29 / W' sa=0 sb=0 sd=0 mult=32 m=32
XM48 net25 I_main net24 net24 sky130_fd_pr__pfet_01v8 L=length W=min_width nf=1 ad='int((nf+1)/2) * W/nf * 0.29' as='int((nf+2)/2) * W/nf * 0.29'
+ pd='2*int((nf+1)/2) * (W/nf + 0.29)' ps='2*int((nf+2)/2) * (W/nf + 0.29)' nrd='0.29 / W' nrs='0.29 / W' sa=0 sb=0 sd=0 mult=32 m=32
XM49 I_out_p T6 net25 net25 sky130_fd_pr__pfet_01v8 L=length W=min_width*switch_multiplier nf=1 ad='int((nf+1)/2) * W/nf * 0.29' as='int((nf+2)/2) * W/nf * 0.29'
+ pd='2*int((nf+1)/2) * (W/nf + 0.29)' ps='2*int((nf+2)/2) * (W/nf + 0.29)' nrd='0.29 / W' nrs='0.29 / W' sa=0 sb=0 sd=0 mult=32 m=32
XM50 I_out_n T6_n net25 net25 sky130_fd_pr__pfet_01v8 L=length W=min_width*switch_multiplier nf=1 ad='int((nf+1)/2) * W/nf * 0.29'
+ as='int((nf+2)/2) * W/nf * 0.29' pd='2*int((nf+1)/2) * (W/nf + 0.29)' ps='2*int((nf+2)/2) * (W/nf + 0.29)' nrd='0.29 / W' nrs='0.29 / W'
+ sa=0 sb=0 sd=0 mult=32 m=32
.ends

* expanding   symbol:  OpAmps/template/OpAmp.sym # of pins=6
** sym_path: /home/david/Documents/Matrix-Vector-Multiplier/analog/library/OpAmps/template/OpAmp.sym
** sch_path: /home/david/Documents/Matrix-Vector-Multiplier/analog/library/OpAmps/template/OpAmp.sch
.subckt OpAmp VDD Vout Vminus Vplus Vbias VSS
*.ipin Vplus
*.ipin Vminus
*.iopin VDD
*.iopin VSS
*.ipin Vbias
*.opin Vout
XM1 net2 Vminus net1 VSS sky130_fd_pr__nfet_01v8 L=0.15 W=16 nf=1 ad='int((nf+1)/2) * W/nf * 0.29' as='int((nf+2)/2) * W/nf * 0.29'
+ pd='2*int((nf+1)/2) * (W/nf + 0.29)' ps='2*int((nf+2)/2) * (W/nf + 0.29)' nrd='0.29 / W' nrs='0.29 / W' sa=0 sb=0 sd=0 mult=1 m=1
XM2 net3 Vplus net1 VSS sky130_fd_pr__nfet_01v8 L=0.15 W=16 nf=1 ad='int((nf+1)/2) * W/nf * 0.29' as='int((nf+2)/2) * W/nf * 0.29'
+ pd='2*int((nf+1)/2) * (W/nf + 0.29)' ps='2*int((nf+2)/2) * (W/nf + 0.29)' nrd='0.29 / W' nrs='0.29 / W' sa=0 sb=0 sd=0 mult=1 m=1
XM3 net2 net2 VDD VDD sky130_fd_pr__pfet_01v8 L=0.4 W=1 nf=1 ad='int((nf+1)/2) * W/nf * 0.29' as='int((nf+2)/2) * W/nf * 0.29' pd='2*int((nf+1)/2) * (W/nf + 0.29)'
+ ps='2*int((nf+2)/2) * (W/nf + 0.29)' nrd='0.29 / W' nrs='0.29 / W' sa=0 sb=0 sd=0 mult=1 m=1
XM4 net3 net2 VDD VDD sky130_fd_pr__pfet_01v8 L=0.4 W=1 nf=1 ad='int((nf+1)/2) * W/nf * 0.29' as='int((nf+2)/2) * W/nf * 0.29' pd='2*int((nf+1)/2) * (W/nf + 0.29)'
+ ps='2*int((nf+2)/2) * (W/nf + 0.29)' nrd='0.29 / W' nrs='0.29 / W' sa=0 sb=0 sd=0 mult=1 m=1
XM5 net1 Vbias VSS VSS sky130_fd_pr__nfet_01v8 L=0.30 W=2 nf=1 ad='int((nf+1)/2) * W/nf * 0.29' as='int((nf+2)/2) * W/nf * 0.29' pd='2*int((nf+1)/2) * (W/nf + 0.29)'
+ ps='2*int((nf+2)/2) * (W/nf + 0.29)' nrd='0.29 / W' nrs='0.29 / W' sa=0 sb=0 sd=0 mult=1 m=1
XM6 Vout net3 VDD VDD sky130_fd_pr__pfet_01v8 L=0.40 W=1 nf=1 ad='int((nf+1)/2) * W/nf * 0.29' as='int((nf+2)/2) * W/nf * 0.29' pd='2*int((nf+1)/2) * (W/nf + 0.29)'
+ ps='2*int((nf+2)/2) * (W/nf + 0.29)' nrd='0.29 / W' nrs='0.29 / W' sa=0 sb=0 sd=0 mult=1 m=1
XC1 Vout net3 sky130_fd_pr__cap_mim_m3_1 W=1 L=1 MF=1 m=1
XM7 Vout Vbias VSS VSS sky130_fd_pr__nfet_01v8 L=0.3 W=1 nf=1 ad='int((nf+1)/2) * W/nf * 0.29' as='int((nf+2)/2) * W/nf * 0.29' pd='2*int((nf+1)/2) * (W/nf + 0.29)'
+ ps='2*int((nf+2)/2) * (W/nf + 0.29)' nrd='0.29 / W' nrs='0.29 / W' sa=0 sb=0 sd=0 mult=1 m=1
.ends

.GLOBAL GND
.GLOBAL VDD
.GLOBAL VSS
.end
