** sch_path: /home/omare/Documents/UWASIC/Matrix-Vector-Analog/analog/schematics/TransAmp.sch
**.subckt TransAmp
V1 net1 GND 3
V2 net2 GND 3
XM1 net1 net2 GND GND sky130_fd_pr__nfet_g5v0d10v5 L=0.5 W=1 nf=1 ad='int((nf+1)/2) * W/nf * 0.29' as='int((nf+2)/2) * W/nf * 0.29'
+ pd='2*int((nf+1)/2) * (W/nf + 0.29)' ps='2*int((nf+2)/2) * (W/nf + 0.29)' nrd='0.29 / W' nrs='0.29 / W'
+ sa=0 sb=0 sd=0 mult=1 m=1
**** begin user architecture code

.control

save all @m.xm1.msky130_fd_pr__nfet_g5v0d10v5[gm]
save all @m.xm1.msky130_fd_pr__nfet_g5v0d10v5[id]
save all @m.xm1.msky130_fd_pr__nfet_g5v0d10v5[gds]

dc V2 0 1.8 0.01

plot @m.xm1.msky130_fd_pr__nfet_g5v0d10v5[id]*1e6
plot @m.xm1.msky130_fd_pr__nfet_g5v0d10v5[gm]*1e6
plot @m.xm1.msky130_fd_pr__nfet_g5v0d10v5[gm]/@m.xm1.msky130_fd_pr__nfet_g5v0d10v5[id] ylimit 0 35
plot @m.xm1.msky130_fd_pr__nfet_g5v0d10v5[gm]/@m.xm1.msky130_fd_pr__nfet_g5v0d10v5[gds] ylimit 0 100

.endc
.end

.lib /home/omare/.volare/sky130A/libs.tech/ngspice/sky130.lib.spice tt
**** end user architecture code
**.ends
.GLOBAL GND
.end
